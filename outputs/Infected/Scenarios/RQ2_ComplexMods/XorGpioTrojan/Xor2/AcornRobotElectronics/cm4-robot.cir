.title KiCad schematic

.model __D16 D

C26 0 SERIAL_CAN_PWR_3.3V 0.1uF
R19 IRQ1 SERIAL_CAN_PWR_3.3V 1k
R20 Net-_U14-_RESET_ SERIAL_CAN_PWR_3.3V 10k
R21 IRQ2 SERIAL_CAN_PWR_3.3V 1k
C25 0 SERIAL_CAN_PWR_3.3V 0.1uF
C21 0 Net-_U13-XTAL1_ 22pF
R18 Net-_U13-_RESET_ SERIAL_CAN_PWR_3.3V 10k
C22 Net-_U13-XTAL2_ 0 22pF
C23 0 Net-_U14-XTAL1_ 22pF
C24 Net-_U14-XTAL2_ 0 22pF
C47 0 Net-_C47-Pad2_ 0.1uF
R2 Net-_D14-K_ ETH_LEDY 470
C43 Net-_C43-Pad1_ 0 1nF
C46 VC1 Net-_C46-Pad2_ 22nF
R44 Net-_C46-Pad2_ Net-_C43-Pad1_ 75R
C45 VC2 Net-_C45-Pad2_ 22nF
R43 Net-_C45-Pad2_ Net-_C43-Pad1_ 75R
R41 Net-_C42-Pad2_ Net-_C43-Pad1_ 75R
C42 VC4 Net-_C42-Pad2_ 22nF
R42 Net-_C44-Pad2_ Net-_C43-Pad1_ 75R
C44 VC3 Net-_C44-Pad2_ 22nF
R15 +3V3 Net-_D17-A_ 56
R1 Net-_D1-K_ Net-_U1-Y_ 1k
R58 0 /LED_3.3V_POWER_NONINV 10k
R13 +3V3 Net-_D12-A_ 27
R37 VOUTN Net-_D25-K_ 249k
C1 VOUTP 0 47uF
R40 Net-_D25-K_ Net-_D24-A_ 51k
R3 Net-_D23-K_ ETH_LEDG 470
D16 VOUTP Net-_D16-K_ __D16
R36 VOUTN VOUTP 24k
C39 VOUTP VOUTN 0.1uF
C48 +3V3 0 10uF
C28 VMOT 0 47uF
C34 VMOT 0 4.7uF
C35 VMOT 0 0.1uF
R50 VMOT /_VIN_5V_EN 100k
R17 FB +12V 1.8Meg
L2 +5V Net-_D11-A_ 10u
C18 +5V 0 4.7uF
C32 5V_switched 0 1uF
C17 +5V 0 10uF
C9 0 +3V3 0.1uF
L1 Net-_D3-K_ +5V 100u
C5 +5V 0 1000uF
C33 +5V 0 47uF
C38 +5V 0 47uF
C20 +12V 0 1uF
C19 +12V FB 22pF
C27 VMOT 0 47uF
R16 0 FB 205k
R9 USB_OTG 0 2.2k
R8 Net-_J3-CC2_ 0 5.1k
R7 0 Net-_J3-CC1_ 5.1k
R11 USBC_VBUS_IN USB_OTG 2.2k
R54 Net-_R53-Pad2_ /VMEAS 50k
R53 VMOT Net-_R53-Pad2_ 50k
R47 +3V3 SER_SELECT 10k
C50 +3V3 0 0.1uF
C51 +3V3 0 1uF
R64 /_VBUS_5V_ENA USBC_VBUS_IN 10k
C41 0 +3V3 0.1uF
R51 0 Net-_JP10-B_ 5.1k
C49 Net-_U32-C1_ 0 0.1uF
C37 +3V3 0 0.1uF
R52 0 Net-_U32-SDO/SA1_ 5.1k
R31 0 Net-_D2-K_ 200
C11 5V_switched 0 0.1uF
R10 PI_n_LED_ACT Net-_D4-K_ 1k
R59 Net-_D30-K1_ 0 130
R60 Net-_D30-K2_ ESTOP_OUT 130
R55 /VMEAS 0 5.1k
R6 Net-_U8-_RESET_ SERIAL_CAN_PWR_3.3V 10k
C31 SERIAL_CAN_PWR_3.3V 0 0.1uF
C14 0 SERIAL_CAN_PWR_3.3V 0.1uF
C15 0 5V_switched_CAN 0.1uF
R34 /CAN0_N Net-_R34-Pad2_ 120
C4 Net-_U9-OSC2_ 0 18pF
C13 0 SERIAL_CAN_PWR_3.3V 0.1uF
C16 0 5V_switched_CAN 0.1uF
C30 SERIAL_CAN_PWR_3.3V 0 0.1uF
R5 Net-_U9-_RESET_ SERIAL_CAN_PWR_3.3V 10k
C8 Net-_U8-OSC2_ 0 18pF
C10 Net-_U8-OSC1_ 0 18pF
R35 /CAN1_N Net-_R35-Pad2_ 120
C7 Net-_U9-OSC1_ 0 18pF
R62 +3V3 Net-_U15-Y_ 10k
R56 ESTOP_SINK_LOCAL +3V3 2.2k
R4 ESTOP_SINK2 +3V3 2.2k
R46 Net-_D29-K_ Net-_U15-A_ 130
R61 +3V3 Net-_U15-A_ 10k
R32 ESTOP_SINK1 +3V3 2.2k
R49 5V_CAN_ENABLE Net-_JP15-A_ 10k
R27 Net-_D8-K_ /ESTOP_SINK_ALL 130
R63 +3V3 /ESTOP_SINK_ALL 10k
R45 Net-_D28-K_ Net-_U15-Y_ 130
R57 /ESTOP_SINK_ALL +3V3 2.2k
R33 +3V3 /root/LED_EN 10k
C54 +5V 0 0.1uF
C6 /HDMI_5v 0 0.1uF
C2 +5V 0 10uF
C3 +5V 0 10uF
R48 +5V Net-_Q9-G_ 10k
R14 +5V Troj_XOR_B 10k
C36 3.3V_PI_OUT 0 0.1uF
R29 3.3V_PI_OUT SCL6 10k
R30 3.3V_PI_OUT SDA6 10k
C12 +3V3 0 0.1uF
C29 +3V3 0 470uF
C53 +3V3 0 0.1uF
C52 0 +3V3 1uF
R24 A1 Net-_Q2-G_ 100
R12 +3V3 SBUS_RX 10k
R22 RC_SBUS Net-_Q5-G_ 100
R25 A2 Net-_Q3-G_ 100
R26 A3 Net-_Q4-G_ 100
R39 USB_SERIAL_D+ /USB_DP 27
R38 USB_SERIAL_D- /USB_DN 27
C40 +3V3 0 0.1uF
R23 +3V3 SDA0_GPIO44 10k
R28 +3V3 SCL0_GPIO45 10k

V_12V +12V 0 DC 12.0
V_3V3 +3V3 0 DC 3.3
V_5V +5V 0 DC 5.0

.control
tran 100u 10m
set filetype=ascii
write ./outputs/Infected/Scenarios/RQ2_ComplexMods/XorGpioTrojan/Xor2/AcornRobotElectronics/cm4-robot_raw.raw all
.endc

.end
