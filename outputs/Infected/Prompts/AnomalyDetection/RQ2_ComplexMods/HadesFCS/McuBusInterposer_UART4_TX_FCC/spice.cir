.title KiCad schematic
BAT1 __BAT1
R1 REG_VIN VIN+ 0.01
C10 +3.3V GND 100n
U1 __U1
C7 +5V REG_FB 4.7n
R5 +5V REG_FB 6.8k
L1 REG_CS +5V 15u
C9 +5V GND 47u
C8 +5V GND 100u
C6 REG_CS Net-_C6-Pad2_ 100n
C5 REG_CS REG_BST 100n
R4 Net-_C6-Pad2_ REG_FB 19.6k
R6 GND REG_FB 1.3k
REG1 __REG1
R7 GND Net-_LED1-K_ 560
LED1 Net-_LED1-K_ +5V G
D1 __D1
R3 REG_PG Net-_D1-A_ 10k
C4 Net-_D1-A_ GND 2.2u
C3 Net-_REG1-PVDD_ GND 2.2u
R2 REG_VIN REG_EN 10k
C1 REG_VIN GND 100u
C2 REG_VIN GND 47u
R8 GND Net-_LED2-K_ 240
REG2 __REG2
LED2 Net-_LED2-K_ +3.3V G
C11 +5V GND 10u
C12 +3.3V GND 10u
HSE1 __HSE1
C32 HSE_IN_FCC GND 10p
C33 Net-_C33-Pad1_ GND 10p
R23 HSE_OUT_FCC Net-_C33-Pad1_ 620
C21 +3V3 GND 100n
R12 +3V3 I2C2_SDA_FCC 4.7k
R11 +3V3 I2C2_SCL_FCC 4.7k
C19 +3V3 GND 100n
C20 +3V3 GND 100n
LED7 Net-_LED7-K_ LED_E_FCC B
R19 GND Net-_LED7-K_ 100
LED8 Net-_LED8-K_ LED_F_FCC B
R20 GND Net-_LED8-K_ 100
R13 +3V3 I2C3_SCL_FCC 4.7k
R14 +3V3 I2C3_SDA_FCC 4.7k
C28 VDDA_FCC GND 100n
R21 VREF+_FCC VDDA_FCC 47
C30 VREF+_FCC GND 100n
C26 +3V3 GND 100n
U11 __U11
C24 +3V3 GND 100n
C22 +3V3 GND 100n
C25 +3V3 GND 100n
C23 +3V3 GND 100n
C14 Net-_FCC1-PH0_ GND 2.2u
C13 unconnected-_C13-Pad1_ GND 2.2u
C31 NRST_FCC GND 100n
SW1 __SW1
R22 Net-_SW2-C_ BOOT0_FCC 10k
SW2 __SW2
FCC1 __FCC1
LED4 Net-_LED4-K_ LED_B_FCC R
R16 GND Net-_LED4-K_ 330
LED5 Net-_LED5-K_ LED_C_FCC Y
LED6 Net-_LED6-K_ LED_D_FCC B
R17 GND Net-_LED5-K_ 330
R18 GND Net-_LED6-K_ 100
TP2 __TP2
TP1 __TP1
R10 +3V3 I2C1_SDA_FCC 4.7k
R9 +3V3 I2C1_SCL_FCC 4.7k
LED3 Net-_LED3-K_ LED_A_FCC R
R15 GND Net-_LED3-K_ 330
C16 +3V3 GND 100n
C17 +3V3 GND 100n
C18 +3V3 GND 100n
R32 HSE_OUT_NAVC Net-_C53-Pad1_ 620
HSE2 __HSE2
C53 Net-_C53-Pad1_ GND 10p
C52 HSE_IN_NAVC GND 10p
R28 +3V3 I2C1_SCL_NAVC 4.7k
LED11 Net-_LED11-K_ LED_C_NAVC Y
LED12 Net-_LED12-K_ LED_D_NAVC B
R35 GND Net-_LED11-K_ 330
R36 GND Net-_LED12-K_ 100
R30 +3V3 I2C3_SCL_NAVC 4.7k
R29 +3V3 I2C1_SDA_NAVC 4.7k
R31 +3V3 I2C3_SDA_NAVC 4.7k
R34 GND Net-_LED10-K_ 330
R33 GND Net-_LED9-K_ 330
LED9 Net-_LED9-K_ LED_A_NAVC R
LED10 Net-_LED10-K_ LED_B_NAVC R
NAVC1 __NAVC1
C38 Net-_NAVC1-PH1_ GND 2.2u
C37 Net-_NAVC1-PH0_ GND 2.2u
C41 +3V3 GND 100n
TP3 __TP3
TP4 __TP4
C40 +3V3 GND 100n
C47 +3V3 GND 100n
C48 +3V3 GND 100n
C43 +3V3 GND 100n
C45 +3V3 GND 100n
C46 +3V3 GND 100n
C42 +3V3 GND 100n
C44 +3V3 GND 100n
C51 VDDA_NAVC GND 100n
SW5 __SW5
C49 NRST_NAVC GND 100n
SW3 __SW3
R26 Net-_SW3-C_ BOOT0_NAVC 10k
R27 Net-_SW4-C_ BOOT1_NAVC 10k
SW4 __SW4
R46 GPIO_G_NAVC GPIO_G_FCC 10
R44 GPIO_E_NAVC GPIO_E_FCC 10
R45 GPIO_F_NAVC GPIO_F_FCC 10
R47 GPIO_H_NAVC GPIO_H_FCC 10
JP2 __JP2
D3 __D3
JP4 __JP4
GPS_BAT1 __GPS_BAT1
R40 GPIO_A_NAVC GPIO_A_FCC 10
JP1 __JP1
USB1 __USB1
R43 GPIO_D_NAVC GPIO_D_FCC 10
R41 GPIO_B_NAVC GPIO_B_FCC 10
R42 GPIO_C_NAVC GPIO_C_FCC 10
R53 USB_DM_FCC Net-_USB1-D-_ 22
R54 USB_ID_FCC Net-_USB1-ID_ 560
D2 __D2
R52 USB_DP_FCC Net-_USB1-D+_ 22
R55 USB_DP_NAVC Net-_USB2-D+_ 22
USB2 __USB2
R56 USB_DM_NAVC Net-_USB2-D-_ 22
R57 USB_ID_NAVC Net-_USB2-ID_ 560
SWD1 __SWD1
SWD2 __SWD2
C69 GND unconnected-_C69-Pad2_ 100n
C68 GND Net-_D4-A_ 100n
USB3 __USB3
USB4 __USB4
LED13 Net-_LED13-K_ Net-_D4-A_ G
R58 GND Net-_LED13-K_ 560
C71 GND unconnected-_C71-Pad2_ 100n
C70 GND Net-_D5-A_ 100n
LED14 Net-_LED14-K_ Net-_D5-A_ G
R59 GND Net-_LED14-K_ 560
R48 UART2_TX_NAVC UART2_RX_FCC 10
R49 UART2_RX_NAVC UART2_TX_FCC 10
D4 __D4
R50 I2C2_SCL_NAVC I2C1_SCL_FCC 0
R51 I2C2_SDA_NAVC I2C1_SDA_FCC 0
D5 __D5
C34 +3.3V GND 100n
U2 __U2
R25 +3.3V Net-_U4-_WP__IO2__ 10k
R24 +3.3V Net-_U4-_HOLD__IO3__ 10k
PWM_SIG1 __PWM_SIG1
PWM_POW1 __PWM_POW1
I2C3_FCC1 __I2C3_FCC1
UART3_FCC1 __UART3_FCC1
UART5_FCC1 __UART5_FCC1
RCIN_FCC1 __RCIN_FCC1
ADC_FCC1 __ADC_FCC1
UART4_FCC1 __UART4_FCC1
U3 __U3
C35 +3.3V GND 100n
U4 __U4
C36 GND +3.3V 100n
C54 +3.3V GND 100n
C55 +3.3V GND 100n
U5 __U5
C65 +3.3V GND 1u
C64 +3.3V GND 1u
C60 +3.3V GND 100n
C59 Net-_U8-C1_ GND 220n
C61 +3.3V GND 100n
U8 __U8
C62 +3.3V GND 10u
U10 __U10
R38 +3.3V GPS_NRST_NAVC 10k
JP3 __JP3
L2 Net-_L2-Pad1_ Net-_ANT1-Pad1_ 27n
C67 Net-_ANT1-Pad1_ GND 10n
C66 Net-_ANT1-Pad1_ Net-_U10-RF_IN_ 22p
R39 Net-_L2-Pad1_ Net-_U10-VCC_RF_ 10
ANT1 __ANT1
U6 __U6
C56 +3.3V GND 100n
U9 __U9
C63 +3.3V GND 100n
GPS_NAVC1 __GPS_NAVC1
UART4_NAVC1 __UART4_NAVC1
I2C3_NAVC1 __I2C3_NAVC1
U7 __U7
C57 Net-_U7-VO-_ Net-_U7-VO+_ 1n
C58 +3.3V GND 100n
R37 +3.3V BAR_NRST_NAVC 10k
.end
