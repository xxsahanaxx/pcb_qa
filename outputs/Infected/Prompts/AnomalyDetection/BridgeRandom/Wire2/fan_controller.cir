.title KiCad schematic

R3 +5V RST 10k
R6 VCC TACH 10k
C1 VCC 0 100n
C2 +5V 0 100n
R1 VCC PWM 10k
R2 PWM Net-_Q2-B_ 1k
R5 /PWM_OUT PWM 1k
R4 TACH /TACH_IN 1k

V_5V +5V 0 DC 5.0
V_VCC VCC 0 DC 5.0

.control
tran 100u 10m
set filetype=ascii
write fan_controller_raw.raw all
.endc

.end
