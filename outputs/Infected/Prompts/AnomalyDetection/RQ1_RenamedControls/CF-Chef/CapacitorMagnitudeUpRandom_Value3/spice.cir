.title KiCad schematic

.model __D1 D
.model __D7 D
.model __D10 D
.model LED D (Is=1p Rs=10 N=1.7)

R6 0 Net-_J10-CC2_ 5.1k
R3 0 Net-_J10-CC1_ 5.1k
C17 +3V3 0 1u
C18 +12V 0 0.1u
R9 Net-_D11-K_ 0 500
D11 Net-_D11-K_ /Microcontroller/NET0005 LED
R7 Net-_U10-GPIO2/ADC1_CH2_ +3V3 10k
D1 NC-D1-0 Net-_D1-A_ __D1
D7 NC-D7-0 Net-_D7-A_ __D7
R8 Net-_D7-A_ +3V3 10k
R1 Net-_D1-A_ +3V3 10k
C5 Net-_U10-EN/CHIP_PU_ 0 10u
R11 Net-_U10-EN/CHIP_PU_ +3V3 10k
C20 +3V3 0 1u
C9 +3V3 0 1u
C2 +3V3 0 1u
C12 +3V3 0 1u
C4 Net-_U11-SW_ Net-_U11-BST_ 100n
C13 VBUS 0 10u
L2 Net-_U11-SW_ +3V3 3.9u
C3 +3V3 0 22u
C14 +3V3 0 22u
D10 0 +12V __D10
C15 Net-_U9-SS_ 0 10n
R2 Net-_U9-ILIM_ 0 51.1k
C8 +12V 0 10u

V_12V +12V 0 DC 12.0
V_3V3 +3V3 0 DC 3.3

.control
tran 100u 10m
set filetype=ascii
write controller_raw.raw all
.endc

.end
