.title KiCad schematic

.model __D2 D
.model __D1 D
.model __D3 D
.model LED D (Is=1p Rs=10 N=1.7)

R11 0 Net-_J8-CC2_ 5.1k
R9 0 Net-_J8-CC1_ 5.1k
C18 +3V3 0 1u
C13 +12V 0 0.1u
R4 Net-_D7-K_ 0 500
D7 Net-_D7-K_ /Microcontroller/NET0003 LED
R10 Net-_U8-GPIO2/ADC1_CH2_ +3V3 10k
D2 NC-D2-0 Net-_D2-A_ __D2
D1 NC-D1-0 Net-_D1-A_ __D1
R7 Net-_D1-A_ +3V3 10k
R3 Net-_D2-A_ +3V3 10k
C1 Net-_U8-EN/CHIP_PU_ 0 10u
R12 Net-_U8-EN/CHIP_PU_ +3V3 10k
C9 +3V3 0 1u
C12 +3V3 0 1u
C19 +3V3 0 1u
C16 +3V3 0 1u
C20 Net-_U11-SW_ Net-_U11-BST_ 100n
C10 VBUS 0 10u
L2 Net-_U11-SW_ +3V3 3.9u
C11 +3V3 0 22u
C6 +3V3 0 22u
D3 0 +12V __D3
C4 Net-_U6-SS_ 0 10n
R8 Net-_U6-ILIM_ 0 51.1k
C14 +12V 0 10u

V_12V +12V 0 DC 12.0
V_3V3 +3V3 0 DC 3.3

.control
tran 100u 10m
set filetype=ascii
write controller_raw.raw all
.endc

.end
