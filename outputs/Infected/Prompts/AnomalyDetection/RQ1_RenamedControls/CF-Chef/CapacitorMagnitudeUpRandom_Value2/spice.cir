.title KiCad schematic

.model __D7 D
.model __D5 D
.model __D2 D
.model LED D (Is=1p Rs=10 N=1.7)

R9 0 Net-_J4-CC2_ 5.1k
R12 0 Net-_J4-CC1_ 5.1k
C18 +3V3 0 1u
C17 +12V 0 0.1u
R11 Net-_D8-K_ 0 500
D8 Net-_D8-K_ /Microcontroller/NET0011 LED
R5 Net-_U5-GPIO2/ADC1_CH2_ +3V3 10k
D7 NC-D7-0 Net-_D7-A_ __D7
D5 NC-D5-0 Net-_D5-A_ __D5
R7 Net-_D5-A_ +3V3 10k
R1 Net-_D7-A_ +3V3 10k
C9 Net-_U5-EN/CHIP_PU_ 0 10u
R4 Net-_U5-EN/CHIP_PU_ +3V3 10k
C15 +3V3 0 1u
C5 +3V3 0 1u
C2 +3V3 0 1u
C14 +3V3 0 1u
C4 Net-_U3-SW_ Net-_U3-BST_ 100n
C8 VBUS 0 10u
L2 Net-_U3-SW_ +3V3 3.9u
C7 +3V3 0 22u
C20 +3V3 0 22u
D2 0 +12V __D2
C16 Net-_U8-SS_ 0 10n
R3 Net-_U8-ILIM_ 0 51.1k
C1 +12V 0 10u

V_12V +12V 0 DC 12.0
V_3V3 +3V3 0 DC 3.3

.control
tran 100u 10m
set filetype=ascii
write controller_raw.raw all
.endc

.end
