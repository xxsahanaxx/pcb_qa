.title KiCad schematic

.model __D7 D
.model __D2 D
.model __D11 D
.model LED D (Is=1p Rs=10 N=1.7)

R1 0 Net-_J2-CC2_ 5.1k
R10 0 Net-_J2-CC1_ 5.1k
C4 +3V3 0 1u
C15 +12V 0 0.1u
R5 Net-_D5-K_ 0 500
D5 Net-_D5-K_ /Microcontroller/NET0002 LED
R7 Net-_U2-GPIO2/ADC1_CH2_ +3V3 10k
D7 NC-D7-0 Net-_D7-A_ __D7
D2 NC-D2-0 Net-_D2-A_ __D2
R4 Net-_D2-A_ +3V3 10k
R11 Net-_D7-A_ +3V3 10k
C17 Net-_U2-EN/CHIP_PU_ 0 10u
R3 Net-_U2-EN/CHIP_PU_ +3V3 10k
C7 +3V3 0 1u
C12 +3V3 0 1u
C10 +3V3 0 1u
C3 +3V3 0 1u
C6 Net-_U9-SW_ Net-_U9-BST_ 100n
C14 VBUS 0 10u
L2 Net-_U9-SW_ +3V3 3.9u
C2 +3V3 0 22u
C16 +3V3 0 22u
D11 0 +12V __D11
C9 Net-_U6-SS_ 0 10n
R8 Net-_U6-ILIM_ 0 51.1k
C20 +12V 0 10u

V_12V +12V 0 DC 12.0
V_3V3 +3V3 0 DC 3.3

.control
tran 100u 10m
set filetype=ascii
write controller_raw.raw all
.endc

.end
