.title KiCad schematic

.model __D9 D
.model __D5 D
.model __D4 D
.model LED D (Is=1p Rs=10 N=1.7)

R8 0 Net-_J5-CC2_ 5.1k
R11 0 Net-_J5-CC1_ 5.1k
C6 +3V3 0 1u
C3 +12V 0 0.1u
R12 Net-_D3-K_ 0 500
D3 Net-_D3-K_ /Microcontroller/NET0003 LED
R10 Net-_U5-GPIO2/ADC1_CH2_ +3V3 10k
D9 NC-D9-0 Net-_D9-A_ __D9
D5 NC-D5-0 Net-_D5-A_ __D5
R2 Net-_D5-A_ +3V3 10k
R6 Net-_D9-A_ +3V3 10k
C16 Net-_U5-EN/CHIP_PU_ 0 10u
R7 Net-_U5-EN/CHIP_PU_ +3V3 10k
C4 +3V3 0 1u
C11 +3V3 0 1u
C14 +3V3 0 1u
C13 +3V3 0 1u
C10 Net-_U1-SW_ Net-_U1-BST_ 100n
C1 VBUS 0 10u
L2 Net-_U1-SW_ +3V3 3.9u
C19 +3V3 0 22u
C20 +3V3 0 22u
D4 0 +12V __D4
C12 Net-_U7-SS_ 0 10n
R1 Net-_U7-ILIM_ 0 51.1k
C18 +12V 0 10u

V_12V +12V 0 DC 12.0
V_3V3 +3V3 0 DC 3.3

.control
tran 100u 10m
set filetype=ascii
write controller_raw.raw all
.endc

.end
