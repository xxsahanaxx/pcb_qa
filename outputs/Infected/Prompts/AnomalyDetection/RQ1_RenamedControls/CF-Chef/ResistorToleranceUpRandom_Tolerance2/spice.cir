.title KiCad schematic

.model __D1 D
.model __D11 D
.model __D10 D
.model LED D (Is=1p Rs=10 N=1.7)

R9 0 Net-_J9-CC2_ 5.1k
R10 0 Net-_J9-CC1_ 5.1k
C4 +3V3 0 1u
C11 +12V 0 0.1u
R5 Net-_D4-K_ 0 500
D4 Net-_D4-K_ /Microcontroller/NET0010 LED
R11 Net-_U7-GPIO2/ADC1_CH2_ +3V3 10k
D1 NC-D1-0 Net-_D1-A_ __D1
D11 NC-D11-0 Net-_D11-A_ __D11
R7 Net-_D11-A_ +3V3 10k
R1 Net-_D1-A_ +3V3 10k
C3 Net-_U7-EN/CHIP_PU_ 0 10u
R12 Net-_U7-EN/CHIP_PU_ +3V3 10k
C17 +3V3 0 1u
C6 +3V3 0 1u
C10 +3V3 0 1u
C2 +3V3 0 1u
C12 Net-_U11-SW_ Net-_U11-BST_ 100n
C1 VBUS 0 10u
L2 Net-_U11-SW_ +3V3 3.9u
C13 +3V3 0 22u
C20 +3V3 0 22u
D10 0 +12V __D10
C19 Net-_U2-SS_ 0 10n
R2 Net-_U2-ILIM_ 0 51.1k
C14 +12V 0 10u

V_12V +12V 0 DC 12.0
V_3V3 +3V3 0 DC 3.3

.control
tran 100u 10m
set filetype=ascii
write controller_raw.raw all
.endc

.end
