.title KiCad schematic

.model __D9 D
.model __D6 D
.model __D8 D
.model LED D (Is=1p Rs=10 N=1.7)

R3 0 Net-_J10-CC2_ 5.1k
R11 0 Net-_J10-CC1_ 5.1k
C15 +3V3 0 1u
C16 +12V 0 0.1u
R12 Net-_D10-K_ 0 500
D10 Net-_D10-K_ /Microcontroller/NET0003 LED
R4 Net-_U6-GPIO2/ADC1_CH2_ +3V3 10k
D9 NC-D9-0 Net-_D9-A_ __D9
D6 NC-D6-0 Net-_D6-A_ __D6
R2 Net-_D6-A_ +3V3 10k
R1 Net-_D9-A_ +3V3 10k
C13 Net-_U6-EN/CHIP_PU_ 0 10u
R10 Net-_U6-EN/CHIP_PU_ +3V3 10k
C17 +3V3 0 1u
C19 +3V3 0 1u
C20 +3V3 0 1u
C2 +3V3 0 1u
C7 Net-_U5-SW_ Net-_U5-BST_ 100n
C12 VBUS 0 10u
L2 Net-_U5-SW_ +3V3 3.9u
C1 +3V3 0 22u
C14 +3V3 0 22u
D8 0 +12V __D8
C4 Net-_U10-SS_ 0 10n
R5 Net-_U10-ILIM_ 0 51.1k
C18 +12V 0 10u

V_12V +12V 0 DC 12.0
V_3V3 +3V3 0 DC 3.3

.control
tran 100u 10m
set filetype=ascii
write controller_raw.raw all
.endc

.end
