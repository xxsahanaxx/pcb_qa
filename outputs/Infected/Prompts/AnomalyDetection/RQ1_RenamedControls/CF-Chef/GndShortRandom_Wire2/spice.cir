.title KiCad schematic

.model __D8 D
.model __D11 D
.model __D5 D
.model LED D (Is=1p Rs=10 N=1.7)

R3 0 Net-_J9-CC2_ 5.1k
R4 0 Net-_J9-CC1_ 5.1k
C15 +3V3 0 1u
C18 +12V 0 0.1u
R2 Net-_D3-K_ 0 500
D3 Net-_D3-K_ /Microcontroller/NET0008 LED
R11 Net-_U11-GPIO2/ADC1_CH2_ +3V3 10k
D8 NC-D8-0 Net-_D8-A_ __D8
D11 NC-D11-0 Net-_D11-A_ __D11
R5 Net-_D11-A_ +3V3 10k
R9 Net-_D8-A_ +3V3 10k
C14 Net-_U11-EN/CHIP_PU_ 0 10u
R7 Net-_U11-EN/CHIP_PU_ +3V3 10k
C12 +3V3 0 1u
C10 +3V3 0 1u
C16 +3V3 0 1u
C5 +3V3 0 1u
C9 Net-_U9-SW_ Net-_U9-BST_ 100n
C2 VBUS 0 10u
L2 Net-_U9-SW_ +3V3 3.9u
C17 +3V3 0 22u
C7 +3V3 0 22u
D5 0 +12V __D5
C4 Net-_U6-SS_ 0 10n
R10 Net-_U6-ILIM_ 0 51.1k
C11 +12V 0 10u

V_12V +12V 0 DC 12.0
V_3V3 +3V3 0 DC 3.3

.control
tran 100u 10m
set filetype=ascii
write controller_raw.raw all
.endc

.end
