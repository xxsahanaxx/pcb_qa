.title KiCad schematic

.model __D5 D
.model __D9 D
.model __D1 D
.model LED D (Is=1p Rs=10 N=1.7)

R4 0 Net-_J3-CC2_ 5.1k
R3 0 Net-_J3-CC1_ 5.1k
C15 +3V3 0 1u
C2 +12V 0 0.1u
R7 Net-_D7-K_ 0 500
D7 Net-_D7-K_ /Microcontroller/NET0013 LED
R11 Net-_U2-GPIO2/ADC1_CH2_ +3V3 10k
D5 NC-D5-0 Net-_D5-A_ __D5
D9 NC-D9-0 Net-_D9-A_ __D9
R5 Net-_D9-A_ +3V3 10k
R1 Net-_D5-A_ +3V3 10k
C19 Net-_U2-EN/CHIP_PU_ 0 10u
R12 Net-_U2-EN/CHIP_PU_ +3V3 10k
C16 +3V3 0 1u
C13 +3V3 0 1u
C3 +3V3 0 1u
C5 +3V3 0 1u
C12 Net-_U6-SW_ Net-_U6-BST_ 100n
C18 VBUS 0 10u
L2 Net-_U6-SW_ +3V3 3.9u
C11 +3V3 0 22u
C6 +3V3 0 22u
D1 0 +12V __D1
C14 Net-_U3-SS_ 0 10n
R10 Net-_U3-ILIM_ 0 51.1k
C17 +12V 0 10u

V_12V +12V 0 DC 12.0
V_3V3 +3V3 0 DC 3.3

.control
tran 100u 10m
set filetype=ascii
write controller_raw.raw all
.endc

.end
