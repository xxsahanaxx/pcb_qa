.title KiCad schematic

.model __D9 D
.model __D7 D
.model __D11 D
.model LED D (Is=1p Rs=10 N=1.7)

R1 0 Net-_J2-CC2_ 5.1k
R4 0 Net-_J2-CC1_ 5.1k
C16 +3V3 0 1u
C4 +12V 0 0.1u
R2 Net-_D8-K_ 0 500
D8 Net-_D8-K_ /Microcontroller/NET0001 LED
R9 Net-_U9-GPIO2/ADC1_CH2_ +3V3 10k
D9 NC-D9-0 Net-_D9-A_ __D9
D7 NC-D7-0 Net-_D7-A_ __D7
R6 Net-_D7-A_ +3V3 10k
R11 Net-_D9-A_ +3V3 10k
C17 Net-_U9-EN/CHIP_PU_ 0 10u
R7 Net-_U9-EN/CHIP_PU_ +3V3 10k
C3 +3V3 0 1u
C10 +3V3 0 1u
C6 +3V3 0 1u
C2 +3V3 0 1u
C15 Net-_U4-SW_ Net-_U4-BST_ 100n
C5 VBUS 0 10u
L2 Net-_U4-SW_ +3V3 3.9u
C1 +3V3 0 22u
C11 +3V3 0 22u
D11 0 +12V __D11
C12 Net-_U2-SS_ 0 10n
R8 Net-_U2-ILIM_ 0 51.1k
C14 +12V 0 10u

V_12V +12V 0 DC 12.0
V_3V3 +3V3 0 DC 3.3

.control
tran 100u 10m
set filetype=ascii
write controller_raw.raw all
.endc

.end
