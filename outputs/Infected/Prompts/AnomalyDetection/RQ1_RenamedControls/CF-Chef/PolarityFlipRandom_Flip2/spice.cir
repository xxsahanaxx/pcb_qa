.title KiCad schematic

.model __D8 D
.model __D9 D
.model __D10 D
.model LED D (Is=1p Rs=10 N=1.7)

R5 0 Net-_J4-CC2_ 5.1k
R4 0 Net-_J4-CC1_ 5.1k
C15 +3V3 0 1u
C3 +12V 0 0.1u
R11 Net-_D4-K_ 0 500
D4 Net-_D4-K_ /Microcontroller/NET0017 LED
R12 Net-_U8-GPIO2/ADC1_CH2_ +3V3 10k
D8 NC-D8-0 Net-_D8-A_ __D8
D9 NC-D9-0 Net-_D9-A_ __D9
R2 Net-_D9-A_ +3V3 10k
R8 Net-_D8-A_ +3V3 10k
C6 Net-_U8-EN/CHIP_PU_ 0 10u
R9 Net-_U8-EN/CHIP_PU_ +3V3 10k
C12 +3V3 0 1u
C2 +3V3 0 1u
C13 +3V3 0 1u
C4 +3V3 0 1u
C19 Net-_U6-SW_ Net-_U6-BST_ 100n
C20 VBUS 0 10u
L2 Net-_U6-SW_ +3V3 3.9u
C1 +3V3 0 22u
C11 +3V3 0 22u
D10 0 +12V __D10
C7 Net-_U2-SS_ 0 10n
R3 Net-_U2-ILIM_ 0 51.1k
C8 +12V 0 10u

V_12V +12V 0 DC 12.0
V_3V3 +3V3 0 DC 3.3

.control
tran 100u 10m
set filetype=ascii
write controller_raw.raw all
.endc

.end
