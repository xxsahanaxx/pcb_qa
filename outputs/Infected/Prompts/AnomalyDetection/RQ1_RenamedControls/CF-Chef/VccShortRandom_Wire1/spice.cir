.title KiCad schematic

.model __D8 D
.model __D6 D
.model __D11 D
.model LED D (Is=1p Rs=10 N=1.7)

R2 0 Net-_J3-CC2_ 5.1k
R5 0 Net-_J3-CC1_ 5.1k
C4 +3V3 0 1u
C15 +12V 0 0.1u
R11 Net-_D5-K_ 0 500
D5 Net-_D5-K_ /Microcontroller/NET0004 LED
R9 Net-_U8-GPIO2/ADC1_CH2_ +3V3 10k
D8 NC-D8-0 Net-_D8-A_ __D8
D6 NC-D6-0 Net-_D6-A_ __D6
R10 Net-_D6-A_ +3V3 10k
R3 Net-_D8-A_ +3V3 10k
C9 Net-_U8-EN/CHIP_PU_ 0 10u
R6 Net-_U8-EN/CHIP_PU_ +3V3 10k
C18 +3V3 0 1u
C5 +3V3 0 1u
C3 +3V3 0 1u
C14 +3V3 0 1u
C17 Net-_U7-SW_ Net-_U7-BST_ 100n
C6 VBUS 0 10u
L2 Net-_U7-SW_ +3V3 3.9u
C20 +3V3 0 22u
C2 +3V3 0 22u
D11 0 +12V __D11
C19 Net-_U11-SS_ 0 10n
R7 Net-_U11-ILIM_ 0 51.1k
C8 +12V 0 10u

V_12V +12V 0 DC 12.0
V_3V3 +3V3 0 DC 3.3

.control
tran 100u 10m
set filetype=ascii
write controller_raw.raw all
.endc

.end
