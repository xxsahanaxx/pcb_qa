.title KiCad schematic

.model __D7 D
.model __D10 D
.model __D4 D
.model LED D (Is=1p Rs=10 N=1.7)

R2 0 Net-_J6-CC2_ 5.1k
R11 0 Net-_J6-CC1_ 5.1k
C15 +3V3 0 1u
C6 +12V 0 0.1u
R12 Net-_D1-K_ 0 500
D1 Net-_D1-K_ /Microcontroller/NET0014 LED
R7 Net-_U5-GPIO2/ADC1_CH2_ +3V3 10k
D7 NC-D7-0 Net-_D7-A_ __D7
D10 NC-D10-0 Net-_D10-A_ __D10
R5 Net-_D10-A_ +3V3 10k
R4 Net-_D7-A_ +3V3 10k
C17 Net-_U5-EN/CHIP_PU_ 0 10u
R10 Net-_U5-EN/CHIP_PU_ +3V3 10k
C10 +3V3 0 1u
C8 +3V3 0 1u
C7 +3V3 0 1u
C4 +3V3 0 1u
C20 Net-_U3-SW_ Net-_U3-BST_ 100n
C1 VBUS 0 10u
L2 Net-_U3-SW_ +3V3 3.9u
C3 +3V3 0 22u
C19 +3V3 0 22u
D4 0 +12V __D4
C11 Net-_U9-SS_ 0 10n
R1 Net-_U9-ILIM_ 0 51.1k
C18 +12V 0 10u

V_12V +12V 0 DC 12.0
V_3V3 +3V3 0 DC 3.3

.control
tran 100u 10m
set filetype=ascii
write controller_raw.raw all
.endc

.end
