.title KiCad schematic

.model __D2 D
.model __D11 D
.model __D1 D
.model LED D (Is=1p Rs=10 N=1.7)

R9 0 Net-_J7-CC2_ 5.1k
R10 0 Net-_J7-CC1_ 5.1k
C14 +3V3 0 1u
C13 +12V 0 0.1u
R2 Net-_D3-K_ 0 500
D3 Net-_D3-K_ /Microcontroller/NET0007 LED
R4 Net-_U3-GPIO2/ADC1_CH2_ +3V3 10k
D2 NC-D2-0 Net-_D2-A_ __D2
D11 NC-D11-0 Net-_D11-A_ __D11
R3 Net-_D11-A_ +3V3 10k
R1 Net-_D2-A_ +3V3 10k
C3 Net-_U3-EN/CHIP_PU_ 0 10u
R12 Net-_U3-EN/CHIP_PU_ +3V3 10k
C18 +3V3 0 1u
C1 +3V3 0 1u
C5 +3V3 0 1u
C19 +3V3 0 1u
C16 Net-_U7-SW_ Net-_U7-BST_ 100n
C2 VBUS 0 10u
L2 Net-_U7-SW_ +3V3 3.9u
C17 +3V3 0 22u
C15 +3V3 0 22u
D1 0 +12V __D1
C7 Net-_U8-SS_ 0 10n
R5 Net-_U8-ILIM_ 0 51.1k
C8 +12V 0 10u

V_12V +12V 0 DC 12.0
V_3V3 +3V3 0 DC 3.3

.control
tran 100u 10m
set filetype=ascii
write controller_raw.raw all
.endc

.end
