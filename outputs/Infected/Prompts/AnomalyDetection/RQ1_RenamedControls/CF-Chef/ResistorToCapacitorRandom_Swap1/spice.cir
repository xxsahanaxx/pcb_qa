.title KiCad schematic

.model __D11 D
.model __D7 D
.model __D8 D
.model LED D (Is=1p Rs=10 N=1.7)

R6 0 Net-_J7-CC2_ 5.1k
R7 0 Net-_J7-CC1_ 5.1k
C18 +3V3 0 1u
C9 +12V 0 0.1u
R5 Net-_D10-K_ 0 500
D10 Net-_D10-K_ /Microcontroller/NET0016 LED
R1 Net-_U6-GPIO2/ADC1_CH2_ +3V3 10k
D11 NC-D11-0 Net-_D11-A_ __D11
D7 NC-D7-0 Net-_D7-A_ __D7
R10 Net-_D7-A_ +3V3 10k
R8 Net-_D11-A_ +3V3 10k
C15 Net-_U6-EN/CHIP_PU_ 0 10u
R12 Net-_U6-EN/CHIP_PU_ +3V3 10k
C19 +3V3 0 1u
C8 +3V3 0 1u
C2 +3V3 0 1u
C5 +3V3 0 1u
C4 Net-_U3-SW_ Net-_U3-BST_ 100n
C20 VBUS 0 10u
L2 Net-_U3-SW_ +3V3 3.9u
C1 +3V3 0 22u
C11 +3V3 0 22u
D8 0 +12V __D8
C6 Net-_U4-SS_ 0 10n
R4 Net-_U4-ILIM_ 0 51.1k
C16 +12V 0 10u

V_12V +12V 0 DC 12.0
V_3V3 +3V3 0 DC 3.3

.control
tran 100u 10m
set filetype=ascii
write controller_raw.raw all
.endc

.end
