.title KiCad schematic

.model __D2 D
.model __D11 D
.model __D6 D
.model LED D (Is=1p Rs=10 N=1.7)

R8 0 Net-_J3-CC2_ 5.1k
R7 0 Net-_J3-CC1_ 5.1k
C7 +3V3 0 1u
C2 +12V 0 0.1u
R5 Net-_D1-K_ 0 500
D1 Net-_D1-K_ /Microcontroller/NET0005 LED
R9 Net-_U4-GPIO2/ADC1_CH2_ +3V3 10k
D2 NC-D2-0 Net-_D2-A_ __D2
D11 NC-D11-0 Net-_D11-A_ __D11
R2 Net-_D11-A_ +3V3 10k
R1 Net-_D2-A_ +3V3 10k
C5 Net-_U4-EN/CHIP_PU_ 0 10u
R10 Net-_U4-EN/CHIP_PU_ +3V3 10k
C17 +3V3 0 1u
C13 +3V3 0 1u
C10 +3V3 0 1u
C20 +3V3 0 1u
C12 Net-_U1-SW_ Net-_U1-BST_ 100n
C1 VBUS 0 10u
L2 Net-_U1-SW_ +3V3 3.9u
C19 +3V3 0 22u
C14 +3V3 0 22u
D6 0 +12V __D6
C9 Net-_U11-SS_ 0 10n
R11 Net-_U11-ILIM_ 0 51.1k
C3 +12V 0 10u

V_12V +12V 0 DC 12.0
V_3V3 +3V3 0 DC 3.3

.control
tran 100u 10m
set filetype=ascii
write controller_raw.raw all
.endc

.end
