.title KiCad schematic

.model __D9 D
.model __D10 D
.model __D6 D
.model LED D (Is=1p Rs=10 N=1.7)

R5 0 Net-_J8-CC2_ 5.1k
R10 0 Net-_J8-CC1_ 5.1k
C5 +3V3 0 1u
C4 +12V 0 0.1u
R8 Net-_D11-K_ 0 500
D11 Net-_D11-K_ /Microcontroller/NET0010 LED
R3 Net-_U10-GPIO2/ADC1_CH2_ +3V3 10k
D9 NC-D9-0 Net-_D9-A_ __D9
D10 NC-D10-0 Net-_D10-A_ __D10
R9 Net-_D10-A_ +3V3 10k
R4 Net-_D9-A_ +3V3 10k
C18 Net-_U10-EN/CHIP_PU_ 0 10u
R1 Net-_U10-EN/CHIP_PU_ +3V3 10k
C10 +3V3 0 1u
C9 +3V3 0 1u
C13 +3V3 0 1u
C16 +3V3 0 1u
C15 Net-_U2-SW_ Net-_U2-BST_ 100n
C19 VBUS 0 10u
L2 Net-_U2-SW_ +3V3 3.9u
C1 +3V3 0 22u
C17 +3V3 0 22u
D6 0 +12V __D6
C2 Net-_U7-SS_ 0 10n
R6 Net-_U7-ILIM_ 0 51.1k
C20 +12V 0 10u

V_12V +12V 0 DC 12.0
V_3V3 +3V3 0 DC 3.3

.control
tran 100u 10m
set filetype=ascii
write controller_raw.raw all
.endc

.end
