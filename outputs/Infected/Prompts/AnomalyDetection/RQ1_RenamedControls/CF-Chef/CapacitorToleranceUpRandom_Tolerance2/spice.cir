.title KiCad schematic

.model __D8 D
.model __D2 D
.model __D9 D
.model LED D (Is=1p Rs=10 N=1.7)

R2 0 Net-_J8-CC2_ 5.1k
R12 0 Net-_J8-CC1_ 5.1k
C8 +3V3 0 1u
C13 +12V 0 0.1u
R4 Net-_D1-K_ 0 500
D1 Net-_D1-K_ /Microcontroller/NET0008 LED
R8 Net-_U5-GPIO2/ADC1_CH2_ +3V3 10k
D8 NC-D8-0 Net-_D8-A_ __D8
D2 NC-D2-0 Net-_D2-A_ __D2
R5 Net-_D2-A_ +3V3 10k
R1 Net-_D8-A_ +3V3 10k
C3 Net-_U5-EN/CHIP_PU_ 0 10u
R9 Net-_U5-EN/CHIP_PU_ +3V3 10k
C6 +3V3 0 1u
C11 +3V3 0 1u
C17 +3V3 0 1u
C4 +3V3 0 1u
C5 Net-_U1-SW_ Net-_U1-BST_ 100n
C7 VBUS 0 10u
L2 Net-_U1-SW_ +3V3 3.9u
C15 +3V3 0 22u
C19 +3V3 0 22u
D9 0 +12V __D9
C9 Net-_U2-SS_ 0 10n
R7 Net-_U2-ILIM_ 0 51.1k
C20 +12V 0 10u

V_12V +12V 0 DC 12.0
V_3V3 +3V3 0 DC 3.3

.control
tran 100u 10m
set filetype=ascii
write controller_raw.raw all
.endc

.end
