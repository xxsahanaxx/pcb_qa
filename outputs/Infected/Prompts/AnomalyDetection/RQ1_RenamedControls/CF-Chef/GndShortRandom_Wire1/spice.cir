.title KiCad schematic

.model __D8 D
.model __D10 D
.model __D4 D
.model LED D (Is=1p Rs=10 N=1.7)

R6 0 Net-_J5-CC2_ 5.1k
R10 0 Net-_J5-CC1_ 5.1k
C5 +3V3 0 1u
C19 +12V 0 0.1u
R9 Net-_D9-K_ 0 500
D9 Net-_D9-K_ /Microcontroller/NET0014 LED
R11 Net-_U11-GPIO2/ADC1_CH2_ +3V3 10k
D8 NC-D8-0 Net-_D8-A_ __D8
D10 NC-D10-0 Net-_D10-A_ __D10
R4 Net-_D10-A_ +3V3 10k
R1 Net-_D8-A_ +3V3 10k
C1 Net-_U11-EN/CHIP_PU_ 0 10u
R8 Net-_U11-EN/CHIP_PU_ +3V3 10k
C17 +3V3 0 1u
C9 +3V3 0 1u
C13 +3V3 0 1u
C2 +3V3 0 1u
C18 Net-_U9-SW_ Net-_U9-BST_ 100n
C10 VBUS 0 10u
L2 Net-_U9-SW_ +3V3 3.9u
C3 +3V3 0 22u
C6 +3V3 0 22u
D4 0 +12V __D4
C8 Net-_U8-SS_ 0 10n
R2 Net-_U8-ILIM_ 0 51.1k
C16 +12V 0 10u

V_12V +12V 0 DC 12.0
V_3V3 +3V3 0 DC 3.3

.control
tran 100u 10m
set filetype=ascii
write controller_raw.raw all
.endc

.end
