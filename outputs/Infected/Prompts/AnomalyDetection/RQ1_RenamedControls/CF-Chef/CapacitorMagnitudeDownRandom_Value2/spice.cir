.title KiCad schematic

.model __D9 D
.model __D7 D
.model __D2 D
.model LED D (Is=1p Rs=10 N=1.7)

R3 0 Net-_J7-CC2_ 5.1k
R11 0 Net-_J7-CC1_ 5.1k
C15 +3V3 0 1u
C8 +12V 0 0.1u
R7 Net-_D4-K_ 0 500
D4 Net-_D4-K_ /Microcontroller/NET0011 LED
R5 Net-_U7-GPIO2/ADC1_CH2_ +3V3 10k
D9 NC-D9-0 Net-_D9-A_ __D9
D7 NC-D7-0 Net-_D7-A_ __D7
R6 Net-_D7-A_ +3V3 10k
R9 Net-_D9-A_ +3V3 10k
C5 Net-_U7-EN/CHIP_PU_ 0 10u
R12 Net-_U7-EN/CHIP_PU_ +3V3 10k
C16 +3V3 0 1u
C2 +3V3 0 1u
C7 +3V3 0 1u
C10 +3V3 0 1u
C14 Net-_U5-SW_ Net-_U5-BST_ 100n
C13 VBUS 0 10u
L2 Net-_U5-SW_ +3V3 3.9u
C1 +3V3 0 22u
C18 +3V3 0 22u
D2 0 +12V __D2
C20 Net-_U2-SS_ 0 10n
R2 Net-_U2-ILIM_ 0 51.1k
C3 +12V 0 10u

V_12V +12V 0 DC 12.0
V_3V3 +3V3 0 DC 3.3

.control
tran 100u 10m
set filetype=ascii
write controller_raw.raw all
.endc

.end
