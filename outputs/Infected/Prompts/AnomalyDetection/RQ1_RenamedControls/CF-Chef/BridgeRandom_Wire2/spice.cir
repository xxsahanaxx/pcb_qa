.title KiCad schematic

.model __D5 D
.model __D10 D
.model __D6 D
.model LED D (Is=1p Rs=10 N=1.7)

R8 0 Net-_J4-CC2_ 5.1k
R9 0 Net-_J4-CC1_ 5.1k
C18 +3V3 0 1u
C12 +12V 0 0.1u
R6 Net-_D11-K_ 0 500
D11 Net-_D11-K_ /Microcontroller/NET0017 LED
R2 Net-_U11-GPIO2/ADC1_CH2_ +3V3 10k
D5 NC-D5-0 Net-_D5-A_ __D5
D10 NC-D10-0 Net-_D10-A_ __D10
R7 Net-_D10-A_ +3V3 10k
R10 Net-_D5-A_ +3V3 10k
C3 Net-_U11-EN/CHIP_PU_ 0 10u
R1 Net-_U11-EN/CHIP_PU_ +3V3 10k
C6 +3V3 0 1u
C17 +3V3 0 1u
C7 +3V3 0 1u
C11 +3V3 0 1u
C1 Net-_U6-SW_ Net-_U6-BST_ 100n
C9 VBUS 0 10u
L2 Net-_U6-SW_ +3V3 3.9u
C10 +3V3 0 22u
C8 +3V3 0 22u
D6 0 +12V __D6
C13 Net-_U8-SS_ 0 10n
R5 Net-_U8-ILIM_ 0 51.1k
C4 +12V 0 10u

V_12V +12V 0 DC 12.0
V_3V3 +3V3 0 DC 3.3

.control
tran 100u 10m
set filetype=ascii
write controller_raw.raw all
.endc

.end
