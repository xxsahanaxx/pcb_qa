.title KiCad schematic

.model __D2 D
.model __D3 D
.model __D9 D
.model LED D (Is=1p Rs=10 N=1.7)

R5 0 Net-_J14-CC2_ 5.1k
R7 0 Net-_J14-CC1_ 5.1k
C10 +3V3 0 1u
C8 +12V 0 0.1u
R6 Net-_D1-K_ 0 500
D1 Net-_D1-K_ /Microcontroller/NET0018 LED
R10 Net-_U9-GPIO2/ADC1_CH2_ +3V3 10k
D2 NC-D2-0 Net-_D2-A_ __D2
D3 NC-D3-0 Net-_D3-A_ __D3
R9 Net-_D3-A_ +3V3 10k
R11 Net-_D2-A_ +3V3 10k
C6 Net-_U9-EN/CHIP_PU_ 0 10u
R3 Net-_U9-EN/CHIP_PU_ +3V3 10k
C11 +3V3 0 1u
C18 +3V3 0 1u
C14 +3V3 0 1u
C1 +3V3 0 1u
C9 Net-_U4-SW_ Net-_U4-BST_ 100n
C3 VBUS 0 10u
L2 Net-_U4-SW_ +3V3 3.9u
C4 +3V3 0 22u
C17 +3V3 0 22u
D9 0 +12V __D9
C13 Net-_U10-SS_ 0 10n
R1 Net-_U10-ILIM_ 0 51.1k
C7 +12V 0 10u

V_12V +12V 0 DC 12.0
V_3V3 +3V3 0 DC 3.3

.control
tran 100u 10m
set filetype=ascii
write controller_raw.raw all
.endc

.end
