.title KiCad schematic

.model __D8 D
.model __D3 D
.model __D5 D
.model LED D (Is=1p Rs=10 N=1.7)

R4 0 Net-_J6-CC2_ 5.1k
R6 0 Net-_J6-CC1_ 5.1k
C1 +3V3 0 1u
C12 +12V 0 0.1u
R5 Net-_D9-K_ 0 500
D9 Net-_D9-K_ /Microcontroller/NET0001 LED
R7 Net-_U10-GPIO2/ADC1_CH2_ +3V3 10k
D8 NC-D8-0 Net-_D8-A_ __D8
D3 NC-D3-0 Net-_D3-A_ __D3
R3 Net-_D3-A_ +3V3 10k
R12 Net-_D8-A_ +3V3 10k
C16 Net-_U10-EN/CHIP_PU_ 0 10u
R8 Net-_U10-EN/CHIP_PU_ +3V3 10k
C14 +3V3 0 1u
C18 +3V3 0 1u
C8 +3V3 0 1u
C10 +3V3 0 1u
C17 Net-_U6-SW_ Net-_U6-BST_ 100n
C6 VBUS 0 10u
L2 Net-_U6-SW_ +3V3 3.9u
C4 +3V3 0 22u
C19 +3V3 0 22u
D5 0 +12V __D5
C3 Net-_U11-SS_ 0 10n
R10 Net-_U11-ILIM_ 0 51.1k
C11 +12V 0 10u

V_12V +12V 0 DC 12.0
V_3V3 +3V3 0 DC 3.3

.control
tran 100u 10m
set filetype=ascii
write controller_raw.raw all
.endc

.end
