.title KiCad schematic

.model __D9 D
.model __D7 D
.model __D2 D
.model LED D (Is=1p Rs=10 N=1.7)

R4 0 Net-_J13-CC2_ 5.1k
R10 0 Net-_J13-CC1_ 5.1k
C10 +3V3 0 1u
C6 +12V 0 0.1u
R11 Net-_D11-K_ 0 500
D11 Net-_D11-K_ /Microcontroller/NET0004 LED
R9 Net-_U11-GPIO2/ADC1_CH2_ +3V3 10k
D9 NC-D9-0 Net-_D9-A_ __D9
D7 NC-D7-0 Net-_D7-A_ __D7
R1 Net-_D7-A_ +3V3 10k
R3 Net-_D9-A_ +3V3 10k
C15 Net-_U11-EN/CHIP_PU_ 0 10u
R8 Net-_U11-EN/CHIP_PU_ +3V3 10k
C20 +3V3 0 1u
C1 +3V3 0 1u
C12 +3V3 0 1u
C3 +3V3 0 1u
C9 Net-_U2-SW_ Net-_U2-BST_ 100n
C5 VBUS 0 10u
L2 Net-_U2-SW_ +3V3 3.9u
C17 +3V3 0 22u
C2 +3V3 0 22u
D2 0 +12V __D2
C4 Net-_U10-SS_ 0 10n
R5 Net-_U10-ILIM_ 0 51.1k
C19 +12V 0 10u

V_12V +12V 0 DC 12.0
V_3V3 +3V3 0 DC 3.3

.control
tran 100u 10m
set filetype=ascii
write controller_raw.raw all
.endc

.end
