.title KiCad schematic

.model __D2 D
.model __D10 D
.model __D8 D
.model LED D (Is=1p Rs=10 N=1.7)

R2 0 Net-_J7-CC2_ 5.1k
R8 0 Net-_J7-CC1_ 5.1k
C1 +3V3 0 1u
C13 +12V 0 0.1u
R10 Net-_D6-K_ 0 500
D6 Net-_D6-K_ /Microcontroller/NET0016 LED
R11 Net-_U3-GPIO2/ADC1_CH2_ +3V3 10k
D2 NC-D2-0 Net-_D2-A_ __D2
D10 NC-D10-0 Net-_D10-A_ __D10
R5 Net-_D10-A_ +3V3 10k
R7 Net-_D2-A_ +3V3 10k
C3 Net-_U3-EN/CHIP_PU_ 0 10u
R1 Net-_U3-EN/CHIP_PU_ +3V3 10k
C20 +3V3 0 1u
C9 +3V3 0 1u
C2 +3V3 0 1u
C16 +3V3 0 1u
C5 Net-_U10-SW_ Net-_U10-BST_ 100n
C4 VBUS 0 10u
L2 Net-_U10-SW_ +3V3 3.9u
C19 +3V3 0 22u
C8 +3V3 0 22u
D8 0 +12V __D8
C12 Net-_U2-SS_ 0 10n
R3 Net-_U2-ILIM_ 0 51.1k
C15 +12V 0 10u

V_12V +12V 0 DC 12.0
V_3V3 +3V3 0 DC 3.3

.control
tran 100u 10m
set filetype=ascii
write controller_raw.raw all
.endc

.end
