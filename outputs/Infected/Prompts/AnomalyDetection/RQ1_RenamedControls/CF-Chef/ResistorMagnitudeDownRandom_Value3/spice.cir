.title KiCad schematic

.model __D8 D
.model __D1 D
.model __D9 D
.model LED D (Is=1p Rs=10 N=1.7)

R9 0 Net-_J13-CC2_ 5.1k
R12 0 Net-_J13-CC1_ 5.1k
C11 +3V3 0 1u
C13 +12V 0 0.1u
R6 Net-_D4-K_ 0 500
D4 Net-_D4-K_ /Microcontroller/NET0003 LED
R2 Net-_U11-GPIO2/ADC1_CH2_ +3V3 10k
D8 NC-D8-0 Net-_D8-A_ __D8
D1 NC-D1-0 Net-_D1-A_ __D1
R10 Net-_D1-A_ +3V3 10k
R5 Net-_D8-A_ +3V3 10k
C20 Net-_U11-EN/CHIP_PU_ 0 10u
R7 Net-_U11-EN/CHIP_PU_ +3V3 10k
C16 +3V3 0 1u
C5 +3V3 0 1u
C7 +3V3 0 1u
C18 +3V3 0 1u
C2 Net-_U6-SW_ Net-_U6-BST_ 100n
C10 VBUS 0 10u
L2 Net-_U6-SW_ +3V3 3.9u
C4 +3V3 0 22u
C3 +3V3 0 22u
D9 0 +12V __D9
C9 Net-_U2-SS_ 0 10n
R8 Net-_U2-ILIM_ 0 51.1k
C14 +12V 0 10u

V_12V +12V 0 DC 12.0
V_3V3 +3V3 0 DC 3.3

.control
tran 100u 10m
set filetype=ascii
write controller_raw.raw all
.endc

.end
