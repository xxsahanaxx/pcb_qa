.title KiCad schematic

.model __D5 D
.model __D7 D
.model __D8 D
.model LED D (Is=1p Rs=10 N=1.7)

R8 0 Net-_J11-CC2_ 5.1k
R7 0 Net-_J11-CC1_ 5.1k
C14 +3V3 0 1u
C6 +12V 0 0.1u
R2 Net-_D6-K_ 0 500
D6 Net-_D6-K_ /Microcontroller/NET0003 LED
R9 Net-_U9-GPIO2/ADC1_CH2_ +3V3 10k
D5 NC-D5-0 Net-_D5-A_ __D5
D7 NC-D7-0 Net-_D7-A_ __D7
R5 Net-_D7-A_ +3V3 10k
R6 Net-_D5-A_ +3V3 10k
C1 Net-_U9-EN/CHIP_PU_ 0 10u
R10 Net-_U9-EN/CHIP_PU_ +3V3 10k
C12 +3V3 0 1u
C15 +3V3 0 1u
C5 +3V3 0 1u
C4 +3V3 0 1u
C19 Net-_U6-SW_ Net-_U6-BST_ 100n
C3 VBUS 0 10u
L2 Net-_U6-SW_ +3V3 3.9u
C13 +3V3 0 22u
C7 +3V3 0 22u
D8 0 +12V __D8
C17 Net-_U7-SS_ 0 10n
R11 Net-_U7-ILIM_ 0 51.1k
C8 +12V 0 10u

V_12V +12V 0 DC 12.0
V_3V3 +3V3 0 DC 3.3

.control
tran 100u 10m
set filetype=ascii
write controller_raw.raw all
.endc

.end
