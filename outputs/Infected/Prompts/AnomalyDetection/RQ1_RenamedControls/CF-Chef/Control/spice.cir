.title KiCad schematic

.model __D9 D
.model __D8 D
.model __D4 D
.model LED D (Is=1p Rs=10 N=1.7)

R3 0 Net-_J1-CC2_ 5.1k
R6 0 Net-_J1-CC1_ 5.1k
C15 +3V3 0 1u
C6 +12V 0 0.1u
R12 Net-_D10-K_ 0 500
D10 Net-_D10-K_ /Microcontroller/NET0004 LED
R1 Net-_U8-GPIO2/ADC1_CH2_ +3V3 10k
D9 NC-D9-0 Net-_D9-A_ __D9
D8 NC-D8-0 Net-_D8-A_ __D8
R9 Net-_D8-A_ +3V3 10k
R4 Net-_D9-A_ +3V3 10k
C14 Net-_U8-EN/CHIP_PU_ 0 10u
R11 Net-_U8-EN/CHIP_PU_ +3V3 10k
C19 +3V3 0 1u
C4 +3V3 0 1u
C11 +3V3 0 1u
C2 +3V3 0 1u
C7 Net-_U4-SW_ Net-_U4-BST_ 100n
C18 VBUS 0 10u
L2 Net-_U4-SW_ +3V3 3.9u
C10 +3V3 0 22u
C12 +3V3 0 22u
D4 0 +12V __D4
C20 Net-_U7-SS_ 0 10n
R8 Net-_U7-ILIM_ 0 51.1k
C16 +12V 0 10u

V_12V +12V 0 DC 12.0
V_3V3 +3V3 0 DC 3.3

.control
tran 100u 10m
set filetype=ascii
write controller_raw.raw all
.endc

.end
