.title KiCad schematic

.model __D9 D
.model __D5 D
.model __D3 D
.model LED D (Is=1p Rs=10 N=1.7)

R1 0 Net-_J7-CC2_ 5.1k
R12 0 Net-_J7-CC1_ 5.1k
C18 +3V3 0 1u
C11 +12V 0 0.1u
R2 Net-_D6-K_ 0 500
D6 Net-_D6-K_ /Microcontroller/NET0008 LED
R9 Net-_U6-GPIO2/ADC1_CH2_ +3V3 10k
D9 NC-D9-0 Net-_D9-A_ __D9
D5 NC-D5-0 Net-_D5-A_ __D5
R10 Net-_D5-A_ +3V3 10k
R4 Net-_D9-A_ +3V3 10k
C6 Net-_U6-EN/CHIP_PU_ 0 10u
R11 Net-_U6-EN/CHIP_PU_ +3V3 10k
C16 +3V3 0 1u
C10 +3V3 0 1u
C7 +3V3 0 1u
C20 +3V3 0 1u
C4 Net-_U3-SW_ Net-_U3-BST_ 100n
C2 VBUS 0 10u
L2 Net-_U3-SW_ +3V3 3.9u
C15 +3V3 0 22u
C8 +3V3 0 22u
D3 0 +12V __D3
C1 Net-_U9-SS_ 0 10n
R5 Net-_U9-ILIM_ 0 51.1k
C9 +12V 0 10u

V_12V +12V 0 DC 12.0
V_3V3 +3V3 0 DC 3.3

.control
tran 100u 10m
set filetype=ascii
write controller_raw.raw all
.endc

.end
