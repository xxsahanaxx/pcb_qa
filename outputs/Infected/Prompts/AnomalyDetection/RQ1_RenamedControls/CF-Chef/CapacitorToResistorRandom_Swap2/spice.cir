.title KiCad schematic

.model __D2 D
.model __D10 D
.model __D1 D
.model LED D (Is=1p Rs=10 N=1.7)

R10 0 Net-_J14-CC2_ 5.1k
R9 0 Net-_J14-CC1_ 5.1k
C16 +3V3 0 1u
C5 +12V 0 0.1u
R7 Net-_D7-K_ 0 500
D7 Net-_D7-K_ /Microcontroller/NET0016 LED
R3 Net-_U11-GPIO2/ADC1_CH2_ +3V3 10k
D2 NC-D2-0 Net-_D2-A_ __D2
D10 NC-D10-0 Net-_D10-A_ __D10
R5 Net-_D10-A_ +3V3 10k
R12 Net-_D2-A_ +3V3 10k
C17 Net-_U11-EN/CHIP_PU_ 0 10u
R4 Net-_U11-EN/CHIP_PU_ +3V3 10k
C15 +3V3 0 1u
C2 +3V3 0 1u
C8 +3V3 0 1u
C20 +3V3 0 1u
C4 Net-_U1-SW_ Net-_U1-BST_ 100n
C18 VBUS 0 10u
L2 Net-_U1-SW_ +3V3 3.9u
C10 +3V3 0 22u
C13 +3V3 0 22u
D1 0 +12V __D1
C3 Net-_U4-SS_ 0 10n
R6 Net-_U4-ILIM_ 0 51.1k
C6 +12V 0 10u

V_12V +12V 0 DC 12.0
V_3V3 +3V3 0 DC 3.3

.control
tran 100u 10m
set filetype=ascii
write controller_raw.raw all
.endc

.end
