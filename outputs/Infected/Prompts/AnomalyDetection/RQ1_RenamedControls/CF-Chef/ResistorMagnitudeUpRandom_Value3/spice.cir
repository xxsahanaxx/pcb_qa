.title KiCad schematic

.model __D5 D
.model __D6 D
.model __D1 D
.model LED D (Is=1p Rs=10 N=1.7)

R5 0 Net-_J4-CC2_ 5.1k
R12 0 Net-_J4-CC1_ 5.1k
C7 +3V3 0 1u
C12 +12V 0 0.1u
R2 Net-_D3-K_ 0 500
D3 Net-_D3-K_ /Microcontroller/NET0012 LED
R10 Net-_U4-GPIO2/ADC1_CH2_ +3V3 10k
D5 NC-D5-0 Net-_D5-A_ __D5
D6 NC-D6-0 Net-_D6-A_ __D6
R9 Net-_D6-A_ +3V3 10k
R11 Net-_D5-A_ +3V3 10k
C15 Net-_U4-EN/CHIP_PU_ 0 10u
R7 Net-_U4-EN/CHIP_PU_ +3V3 10k
C2 +3V3 0 1u
C13 +3V3 0 1u
C5 +3V3 0 1u
C18 +3V3 0 1u
C9 Net-_U3-SW_ Net-_U3-BST_ 100n
C6 VBUS 0 10u
L2 Net-_U3-SW_ +3V3 3.9u
C16 +3V3 0 22u
C4 +3V3 0 22u
D1 0 +12V __D1
C14 Net-_U2-SS_ 0 10n
R8 Net-_U2-ILIM_ 0 51.1k
C11 +12V 0 10u

V_12V +12V 0 DC 12.0
V_3V3 +3V3 0 DC 3.3

.control
tran 100u 10m
set filetype=ascii
write controller_raw.raw all
.endc

.end
