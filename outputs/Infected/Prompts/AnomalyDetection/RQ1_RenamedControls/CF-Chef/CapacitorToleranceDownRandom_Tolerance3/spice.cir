.title KiCad schematic

.model __D7 D
.model __D5 D
.model __D8 D
.model LED D (Is=1p Rs=10 N=1.7)

R5 0 Net-_J4-CC2_ 5.1k
R11 0 Net-_J4-CC1_ 5.1k
C19 +3V3 0 1u
C9 +12V 0 0.1u
R2 Net-_D1-K_ 0 500
D1 Net-_D1-K_ /Microcontroller/NET0011 LED
R10 Net-_U2-GPIO2/ADC1_CH2_ +3V3 10k
D7 NC-D7-0 Net-_D7-A_ __D7
D5 NC-D5-0 Net-_D5-A_ __D5
R8 Net-_D5-A_ +3V3 10k
R7 Net-_D7-A_ +3V3 10k
C2 Net-_U2-EN/CHIP_PU_ 0 10u
R3 Net-_U2-EN/CHIP_PU_ +3V3 10k
C6 +3V3 0 1u
C18 +3V3 0 1u
C15 +3V3 0 1u
C16 +3V3 0 1u
C1 Net-_U10-SW_ Net-_U10-BST_ 100n
C10 VBUS 0 10u
L2 Net-_U10-SW_ +3V3 3.9u
C3 +3V3 0 22u
C5 +3V3 0 22u
D8 0 +12V __D8
C17 Net-_U3-SS_ 0 10n
R6 Net-_U3-ILIM_ 0 51.1k
C11 +12V 0 10u

V_12V +12V 0 DC 12.0
V_3V3 +3V3 0 DC 3.3

.control
tran 100u 10m
set filetype=ascii
write controller_raw.raw all
.endc

.end
