.title KiCad schematic

.model __D9 D
.model __D7 D
.model __D4 D
.model LED D (Is=1p Rs=10 N=1.7)

R8 0 Net-_J10-CC2_ 5.1k
R6 0 Net-_J10-CC1_ 5.1k
C13 +3V3 0 1u
C8 +12V 0 0.1u
R11 Net-_D1-K_ 0 500
D1 Net-_D1-K_ /Microcontroller/NET0005 LED
R4 Net-_U11-GPIO2/ADC1_CH2_ +3V3 10k
D9 NC-D9-0 Net-_D9-A_ __D9
D7 NC-D7-0 Net-_D7-A_ __D7
R1 Net-_D7-A_ +3V3 10k
R10 Net-_D9-A_ +3V3 10k
C2 Net-_U11-EN/CHIP_PU_ 0 10u
R12 Net-_U11-EN/CHIP_PU_ +3V3 10k
C1 +3V3 0 1u
C5 +3V3 0 1u
C16 +3V3 0 1u
C18 +3V3 0 1u
C14 Net-_U5-SW_ Net-_U5-BST_ 100n
C15 VBUS 0 10u
L2 Net-_U5-SW_ +3V3 3.9u
C3 +3V3 0 22u
C11 +3V3 0 22u
D4 0 +12V __D4
C19 Net-_U1-SS_ 0 10n
R2 Net-_U1-ILIM_ 0 51.1k
C10 +12V 0 10u

V_12V +12V 0 DC 12.0
V_3V3 +3V3 0 DC 3.3

.control
tran 100u 10m
set filetype=ascii
write controller_raw.raw all
.endc

.end
