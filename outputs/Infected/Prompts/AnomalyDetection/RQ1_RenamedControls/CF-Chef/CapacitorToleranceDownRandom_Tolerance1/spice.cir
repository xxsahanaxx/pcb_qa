.title KiCad schematic

.model __D7 D
.model __D11 D
.model __D8 D
.model LED D (Is=1p Rs=10 N=1.7)

R2 0 Net-_J14-CC2_ 5.1k
R12 0 Net-_J14-CC1_ 5.1k
C20 +3V3 0 1u
C10 +12V 0 0.1u
R4 Net-_D4-K_ 0 500
D4 Net-_D4-K_ /Microcontroller/NET0009 LED
R9 Net-_U9-GPIO2/ADC1_CH2_ +3V3 10k
D7 NC-D7-0 Net-_D7-A_ __D7
D11 NC-D11-0 Net-_D11-A_ __D11
R6 Net-_D11-A_ +3V3 10k
R3 Net-_D7-A_ +3V3 10k
C2 Net-_U9-EN/CHIP_PU_ 0 10u
R8 Net-_U9-EN/CHIP_PU_ +3V3 10k
C16 +3V3 0 1u
C19 +3V3 0 1u
C7 +3V3 0 1u
C18 +3V3 0 1u
C17 Net-_U1-SW_ Net-_U1-BST_ 100n
C12 VBUS 0 10u
L2 Net-_U1-SW_ +3V3 3.9u
C1 +3V3 0 22u
C9 +3V3 0 22u
D8 0 +12V __D8
C11 Net-_U10-SS_ 0 10n
R11 Net-_U10-ILIM_ 0 51.1k
C5 +12V 0 10u

V_12V +12V 0 DC 12.0
V_3V3 +3V3 0 DC 3.3

.control
tran 100u 10m
set filetype=ascii
write controller_raw.raw all
.endc

.end
