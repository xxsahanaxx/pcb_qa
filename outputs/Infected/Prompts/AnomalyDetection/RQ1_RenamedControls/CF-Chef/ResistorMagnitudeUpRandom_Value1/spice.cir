.title KiCad schematic

.model __D7 D
.model __D3 D
.model __D8 D
.model LED D (Is=1p Rs=10 N=1.7)

R3 0 Net-_J3-CC2_ 5.1k
R12 0 Net-_J3-CC1_ 5.1k
C20 +3V3 0 1u
C8 +12V 0 0.1u
R6 Net-_D1-K_ 0 500
D1 Net-_D1-K_ /Microcontroller/NET0016 LED
R4 Net-_U2-GPIO2/ADC1_CH2_ +3V3 10k
D7 NC-D7-0 Net-_D7-A_ __D7
D3 NC-D3-0 Net-_D3-A_ __D3
R5 Net-_D3-A_ +3V3 10k
R1 Net-_D7-A_ +3V3 10k
C4 Net-_U2-EN/CHIP_PU_ 0 10u
R10 Net-_U2-EN/CHIP_PU_ +3V3 10k
C14 +3V3 0 1u
C11 +3V3 0 1u
C1 +3V3 0 1u
C5 +3V3 0 1u
C17 Net-_U11-SW_ Net-_U11-BST_ 100n
C16 VBUS 0 10u
L2 Net-_U11-SW_ +3V3 3.9u
C2 +3V3 0 22u
C19 +3V3 0 22u
D8 0 +12V __D8
C18 Net-_U3-SS_ 0 10n
R9 Net-_U3-ILIM_ 0 51.1k
C13 +12V 0 10u

V_12V +12V 0 DC 12.0
V_3V3 +3V3 0 DC 3.3

.control
tran 100u 10m
set filetype=ascii
write controller_raw.raw all
.endc

.end
