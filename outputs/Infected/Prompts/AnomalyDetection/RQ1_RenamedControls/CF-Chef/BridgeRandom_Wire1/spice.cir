.title KiCad schematic

.model __D7 D
.model __D2 D
.model __D6 D
.model LED D (Is=1p Rs=10 N=1.7)

R11 0 Net-_J9-CC2_ 5.1k
R10 0 Net-_J9-CC1_ 5.1k
C11 +3V3 0 1u
C3 +12V 0 0.1u
R6 Net-_D8-K_ 0 500
D8 Net-_D8-K_ /Microcontroller/NET0002 LED
R2 Net-_U3-GPIO2/ADC1_CH2_ +3V3 10k
D7 NC-D7-0 Net-_D7-A_ __D7
D2 NC-D2-0 Net-_D2-A_ __D2
R9 Net-_D2-A_ +3V3 10k
R7 Net-_D7-A_ +3V3 10k
C4 Net-_U3-EN/CHIP_PU_ 0 10u
R4 Net-_U3-EN/CHIP_PU_ +3V3 10k
C18 +3V3 0 1u
C2 +3V3 0 1u
C15 +3V3 0 1u
C16 +3V3 0 1u
C1 Net-_U5-SW_ Net-_U5-BST_ 100n
C13 VBUS 0 10u
L2 Net-_U5-SW_ +3V3 3.9u
C8 +3V3 0 22u
C6 +3V3 0 22u
D6 0 +12V __D6
C17 Net-_U8-SS_ 0 10n
R8 Net-_U8-ILIM_ 0 51.1k
C5 +12V 0 10u

V_12V +12V 0 DC 12.0
V_3V3 +3V3 0 DC 3.3

.control
tran 100u 10m
set filetype=ascii
write controller_raw.raw all
.endc

.end
