.title KiCad schematic

.model __D1 D
.model __D6 D
.model __D2 D
.model LED D (Is=1p Rs=10 N=1.7)

R4 0 Net-_J6-CC2_ 5.1k
R3 0 Net-_J6-CC1_ 5.1k
C8 +3V3 0 1u
C12 +12V 0 0.1u
R11 Net-_D9-K_ 0 500
D9 Net-_D9-K_ /Microcontroller/NET0017 LED
R8 Net-_U8-GPIO2/ADC1_CH2_ +3V3 10k
D1 NC-D1-0 Net-_D1-A_ __D1
D6 NC-D6-0 Net-_D6-A_ __D6
R9 Net-_D6-A_ +3V3 10k
R7 Net-_D1-A_ +3V3 10k
C10 Net-_U8-EN/CHIP_PU_ 0 10u
R2 Net-_U8-EN/CHIP_PU_ +3V3 10k
C20 +3V3 0 1u
C2 +3V3 0 1u
C6 +3V3 0 1u
C13 +3V3 0 1u
C18 Net-_U3-SW_ Net-_U3-BST_ 100n
C5 VBUS 0 10u
L2 Net-_U3-SW_ +3V3 3.9u
C14 +3V3 0 22u
C7 +3V3 0 22u
D2 0 +12V __D2
C4 Net-_U9-SS_ 0 10n
R1 Net-_U9-ILIM_ 0 51.1k
C15 +12V 0 10u

V_12V +12V 0 DC 12.0
V_3V3 +3V3 0 DC 3.3

.control
tran 100u 10m
set filetype=ascii
write controller_raw.raw all
.endc

.end
