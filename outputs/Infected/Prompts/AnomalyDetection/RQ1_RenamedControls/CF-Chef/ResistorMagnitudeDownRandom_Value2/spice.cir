.title KiCad schematic

.model __D11 D
.model __D2 D
.model __D5 D
.model LED D (Is=1p Rs=10 N=1.7)

R8 0 Net-_J2-CC2_ 5.1k
R11 0 Net-_J2-CC1_ 5.1k
C1 +3V3 0 1u
C15 +12V 0 0.1u
R4 Net-_D8-K_ 0 500
D8 Net-_D8-K_ /Microcontroller/NET0014 LED
R5 Net-_U8-GPIO2/ADC1_CH2_ +3V3 10k
D11 NC-D11-0 Net-_D11-A_ __D11
D2 NC-D2-0 Net-_D2-A_ __D2
R7 Net-_D2-A_ +3V3 10k
R3 Net-_D11-A_ +3V3 10k
C3 Net-_U8-EN/CHIP_PU_ 0 10u
R10 Net-_U8-EN/CHIP_PU_ +3V3 10k
C4 +3V3 0 1u
C10 +3V3 0 1u
C9 +3V3 0 1u
C12 +3V3 0 1u
C11 Net-_U3-SW_ Net-_U3-BST_ 100n
C18 VBUS 0 10u
L2 Net-_U3-SW_ +3V3 3.9u
C2 +3V3 0 22u
C8 +3V3 0 22u
D5 0 +12V __D5
C13 Net-_U4-SS_ 0 10n
R1 Net-_U4-ILIM_ 0 51.1k
C16 +12V 0 10u

V_12V +12V 0 DC 12.0
V_3V3 +3V3 0 DC 3.3

.control
tran 100u 10m
set filetype=ascii
write controller_raw.raw all
.endc

.end
