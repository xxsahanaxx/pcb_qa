.title KiCad schematic

.model __D9 D
.model __D6 D
.model __D3 D
.model LED D (Is=1p Rs=10 N=1.7)

R9 0 Net-_J6-CC2_ 5.1k
R5 0 Net-_J6-CC1_ 5.1k
C2 +3V3 0 1u
C7 +12V 0 0.1u
R2 Net-_D1-K_ 0 500
D1 Net-_D1-K_ /Microcontroller/NET0004 LED
R12 Net-_U4-GPIO2/ADC1_CH2_ +3V3 10k
D9 NC-D9-0 Net-_D9-A_ __D9
D6 NC-D6-0 Net-_D6-A_ __D6
R8 Net-_D6-A_ +3V3 10k
R7 Net-_D9-A_ +3V3 10k
C13 Net-_U4-EN/CHIP_PU_ 0 10u
R10 Net-_U4-EN/CHIP_PU_ +3V3 10k
C14 +3V3 0 1u
C10 +3V3 0 1u
C8 +3V3 0 1u
C15 +3V3 0 1u
C20 Net-_U9-SW_ Net-_U9-BST_ 100n
C6 VBUS 0 10u
L2 Net-_U9-SW_ +3V3 3.9u
C5 +3V3 0 22u
C9 +3V3 0 22u
D3 0 +12V __D3
C16 Net-_U7-SS_ 0 10n
R1 Net-_U7-ILIM_ 0 51.1k
C4 +12V 0 10u

V_12V +12V 0 DC 12.0
V_3V3 +3V3 0 DC 3.3

.control
tran 100u 10m
set filetype=ascii
write controller_raw.raw all
.endc

.end
