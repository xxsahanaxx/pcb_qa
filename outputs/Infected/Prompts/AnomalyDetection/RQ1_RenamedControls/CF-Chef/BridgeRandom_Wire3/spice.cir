.title KiCad schematic

.model __D1 D
.model __D11 D
.model __D8 D
.model LED D (Is=1p Rs=10 N=1.7)

R9 0 Net-_J11-CC2_ 5.1k
R5 0 Net-_J11-CC1_ 5.1k
C16 +3V3 0 1u
C9 +12V 0 0.1u
R4 Net-_D5-K_ 0 500
D5 Net-_D5-K_ /Microcontroller/NET0008 LED
R1 Net-_U5-GPIO2/ADC1_CH2_ +3V3 10k
D1 NC-D1-0 Net-_D1-A_ __D1
D11 NC-D11-0 Net-_D11-A_ __D11
R12 Net-_D11-A_ +3V3 10k
R7 Net-_D1-A_ +3V3 10k
C1 Net-_U5-EN/CHIP_PU_ 0 10u
R11 Net-_U5-EN/CHIP_PU_ +3V3 10k
C20 +3V3 0 1u
C5 +3V3 0 1u
C3 +3V3 0 1u
C13 +3V3 0 1u
C19 Net-_U6-SW_ Net-_U6-BST_ 100n
C8 VBUS 0 10u
L2 Net-_U6-SW_ +3V3 3.9u
C12 +3V3 0 22u
C2 +3V3 0 22u
D8 0 +12V __D8
C6 Net-_U7-SS_ 0 10n
R3 Net-_U7-ILIM_ 0 51.1k
C17 +12V 0 10u

V_12V +12V 0 DC 12.0
V_3V3 +3V3 0 DC 3.3

.control
tran 100u 10m
set filetype=ascii
write controller_raw.raw all
.endc

.end
