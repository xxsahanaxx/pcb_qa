.title KiCad schematic

.model __D5 D
.model __D1 D
.model __D4 D
.model LED D (Is=1p Rs=10 N=1.7)

R11 0 Net-_J2-CC2_ 5.1k
R3 0 Net-_J2-CC1_ 5.1k
C17 +3V3 0 1u
C20 +12V 0 0.1u
R7 Net-_D3-K_ 0 500
D3 Net-_D3-K_ /Microcontroller/NET0007 LED
R12 Net-_U4-GPIO2/ADC1_CH2_ +3V3 10k
D5 NC-D5-0 Net-_D5-A_ __D5
D1 NC-D1-0 Net-_D1-A_ __D1
R9 Net-_D1-A_ +3V3 10k
R5 Net-_D5-A_ +3V3 10k
C14 Net-_U4-EN/CHIP_PU_ 0 10u
R2 Net-_U4-EN/CHIP_PU_ +3V3 10k
C6 +3V3 0 1u
C15 +3V3 0 1u
C9 +3V3 0 1u
C10 +3V3 0 1u
C18 Net-_U5-SW_ Net-_U5-BST_ 100n
C3 VBUS 0 10u
L2 Net-_U5-SW_ +3V3 3.9u
C7 +3V3 0 22u
C5 +3V3 0 22u
D4 0 +12V __D4
C8 Net-_U11-SS_ 0 10n
R6 Net-_U11-ILIM_ 0 51.1k
C19 +12V 0 10u

V_12V +12V 0 DC 12.0
V_3V3 +3V3 0 DC 3.3

.control
tran 100u 10m
set filetype=ascii
write controller_raw.raw all
.endc

.end
