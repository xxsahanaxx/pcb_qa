.title KiCad schematic

C31 0 +24V 100n
C48 0 +3V3 10u
C73 0 +3V3 100n
C53 NET0058 +3V3 100n
R32 NET0057 +3V3 10k
R48 0 NET0058 10k
C29 0 NET0057 100n
C3 +5V 0 100u
R3 NET0003 /NET0068 100
R10 0 /NET0068 10k
C21 0 +24V 100n
C43 +24V 0 47u
R11 NET0057 /NET0070 4.7k
R35 NET0058 /NET0008 4.7k
R33 NET0064 /NET0088 100
C70 +24V 0 220u
R2 /NET0088 +3V3 10k
C87 0 +3V3 100n
C85 /NET0043 /NET0025 22n
C27 0 pH 2.2u
C32 0 +3V3 100n
C60 +24V 0 220u
R20 0 /VREFpH 10.7k
R56 /VREFpH pH 14k
C94 /NET0032 +24V 100n
C52 /NET0081 /NET0005 22n
C30 0 +24V 100n
C24 0 +24V 100n
R25 /NET0029 0 110m
R31 /NET0030 0 110m
C83 0 +24V 100n
C36 /NET0079 +24V 100n
C86 0 +24V 100n
C25 +24V 0 220u
C74 +24V 0 220u
C62 +24V 0 1000u
R17 /NET0071 /+24VF 33k
C50 0 +24V 10u
C65 0 +24V 100n
R22 NET0017 +3V3 2.2k
R29 NET0084 +3V3 2.2k
R26 Net-_M4A-TX1/IO22_ NET0076 1k
C84 /NET0097 /0ISOEC 10n
C44 /NET0097 /0ISOEC 100n
R55 /NET0053 /NET0097 2.2k
R12 /NET0022 /NET0097 2.2k
R7 /NET0085 /NET0097 16.9k
C89 0 +3V3 100n
C68 0 +3V3 10u
C63 /0ISOEC /NET0078 100n
C33 /0ISOEC /NET0078 10u
C7 0 +5V 10u
R37 8BK +5V 52.3k
R23 0 8BK 10k
C39 +5V 0 220u
C12 0 +5V 10u
C69 0 +5V 10u
C72 0 +3V3 22u
C77 /NET0050 /0ISOpH 100n
C20 /0ISOpH /NET0031 10u
R13 /NET0006 /NET0050 2.2k
R8 /NET0044 /NET0050 2.2k
C14 0 +3V3 100n
C41 0 +3V3 10u
R15 /NET0085 /0ISOEC 10k
C35 0 +3V3 10u
C71 +3V3 0 10n
C51 0 +3V3 100n
C9 +3V3 0 100n
L2 /+5VBK +5V 10u
C88 /NET0093 /+5VBK 100n
C54 0 /NET0062 33n
R40 0 /NET0049 21k
R45 /NET0077 /0ISOpH 10k
R50 /NET0077 /NET0050 16.9k
C95 /NET0050 /0ISOpH 10n
C57 /0ISOpH /NET0031 100n
C66 +3V3 0 100n
C16 +3V3 0 10n
C17 0 +3V3 100n
C56 0 +3V3 10u
C10 0 NA 2.2u
R9 0 /VREFNA 10.7k
R49 /VREFNA NA 14k
C22 0 +24V 100n
C6 0 +24V 100n
C8 /NET0014 +24V 100n
C90 /NET0019 /NET0091 22n
C76 0 +3V3 100n
R51 /NET0027 0 110m
R27 /NET0010 0 110m
R24 /VREFNB NB 14k
C19 0 NB 2.2u
R4 0 /VREFNB 10.7k
R5 /NET0051 0 110m
R30 /NET0089 0 110m

V_24V +24V 0 DC 24.0
V_3V3 +3V3 0 DC 3.3
V_5V +5V 0 DC 5.0

.control
tran 100u 10m
set filetype=ascii
write OPNhydro_r2_raw.raw all
.endc

.end
