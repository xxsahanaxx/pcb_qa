.title KiCad schematic

C43 0 +24V 100n
C34 0 +3V3 10u
C2 0 +3V3 100n
C9 NET0011 +3V3 100n
R5 NET0006 +3V3 10k
R37 0 NET0011 10k
C23 0 NET0006 100n
C27 +5V 0 100u
R53 NET0084 /NET0059 100
R44 0 /NET0059 10k
C4 0 +24V 100n
C44 +24V 0 47u
R48 NET0006 /NET0060 4.7k
R54 NET0011 /NET0016 4.7k
R21 NET0090 /NET0089 100
C61 +24V 0 220u
R16 /NET0089 +3V3 10k
C42 0 +3V3 100n
C59 /NET0005 /NET0099 22n
C52 0 pH 2.2u
C47 0 +3V3 100n
C57 +24V 0 220u
R50 0 /VREFpH 10.7k
R13 /VREFpH pH 14k
C88 /NET0070 +24V 100n
C33 /NET0086 /NET0024 22n
C76 0 +24V 100n
C65 0 +24V 100n
R17 /NET0014 0 110m
R46 /NET0012 0 110m
C6 0 +24V 100n
C38 /NET0069 +24V 100n
C68 0 +24V 100n
C19 +24V 0 220u
C82 +24V 0 220u
C56 +24V 0 1000u
R33 /NET0055 /+24VF 33k
C73 0 +24V 10u
C78 0 +24V 100n
R40 NET0009 +3V3 2.2k
R15 NET0022 +3V3 2.2k
R56 Net-_M3A-TX1/IO22_ NET0030 1k
C36 /NET0095 /0ISOEC 10n
C92 /NET0095 /0ISOEC 100n
R38 /NET0026 /NET0095 2.2k
R55 /NET0064 /NET0095 2.2k
R10 /NET0017 /NET0095 16.9k
C5 0 +3V3 100n
C3 0 +3V3 10u
C49 /0ISOEC /NET0033 100n
C17 /0ISOEC /NET0033 10u
C8 0 +5V 10u
R47 8BK +5V 52.3k
R4 0 8BK 10k
C10 +5V 0 220u
C22 0 +5V 10u
C85 0 +5V 10u
C28 0 +3V3 22u
C15 /NET0098 /0ISOpH 100n
C62 /0ISOpH /NET0020 10u
R20 /NET0082 /NET0098 2.2k
R24 /NET0027 /NET0098 2.2k
C89 0 +3V3 100n
C83 0 +3V3 10u
R34 /NET0017 /0ISOEC 10k
C45 0 +3V3 10u
C14 +3V3 0 10n
C16 0 +3V3 100n
C53 +3V3 0 100n
L2 /+5VBK +5V 10u
C37 /NET0001 /+5VBK 100n
C79 0 /NET0078 33n
R30 0 /NET0019 21k
R35 /NET0053 /0ISOpH 10k
R29 /NET0053 /NET0098 16.9k
C70 /NET0098 /0ISOpH 10n
C54 /0ISOpH /NET0020 100n
C18 +3V3 0 100n
C39 +3V3 0 10n
C96 0 +3V3 100n
C21 0 +3V3 10u
C55 0 NA 2.2u
R41 0 /VREFNA 10.7k
R43 /VREFNA NA 14k
C80 0 +24V 100n
C84 0 +24V 100n
C77 /NET0074 +24V 100n
C81 /NET0065 /NET0018 22n
C46 0 +3V3 100n
R51 /NET0003 0 110m
R36 /NET0067 0 110m
R18 /VREFNB NB 14k
C67 0 NB 2.2u
R9 0 /VREFNB 10.7k
R19 /NET0076 0 110m
R2 /NET0013 0 110m

V_24V +24V 0 DC 24.0
V_3V3 +3V3 0 DC 3.3
V_5V +5V 0 DC 5.0

.control
tran 100u 10m
set filetype=ascii
write OPNhydro_r2_raw.raw all
.endc

.end
