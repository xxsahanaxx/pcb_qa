.title KiCad schematic

C66 0 +24V 100n
C93 0 +3V3 10u
C43 0 +3V3 100n
C80 NET0006 +3V3 100n
R29 NET0009 +3V3 10k
R5 0 NET0006 10k
C24 0 NET0009 100n
C18 +5V 0 100u
R31 NET0076 /NET0073 100
R4 0 /NET0073 10k
C42 0 +24V 100n
C95 +24V 0 47u
R17 NET0009 /NET0001 4.7k
R24 NET0006 /NET0084 4.7k
R3 NET0013 /NET0037 100
C53 +24V 0 220u
R46 /NET0037 +3V3 10k
C22 0 +3V3 100n
C71 /NET0041 /NET0057 22n
C82 0 pH 2.2u
C39 0 +3V3 100n
C89 +24V 0 220u
R45 0 /VREFpH 10.7k
R27 /VREFpH pH 14k
C30 /NET0062 +24V 100n
C45 /NET0064 /NET0014 22n
C2 0 +24V 100n
C91 0 +24V 100n
R12 /NET0049 0 110m
R6 /NET0070 0 110m
C87 0 +24V 100n
C57 /NET0007 +24V 100n
C59 0 +24V 100n
C69 +24V 0 220u
C61 +24V 0 220u
C16 +24V 0 1000u
R47 /NET0058 /+24VF 33k
C48 0 +24V 10u
C74 0 +24V 100n
R33 NET0066 +3V3 2.2k
R36 NET0048 +3V3 2.2k
R53 Net-_M5A-TX1/IO22_ NET0027 1k
C12 /NET0045 /0ISOEC 10n
C56 /NET0045 /0ISOEC 100n
R51 /NET0004 /NET0045 2.2k
R49 /NET0094 /NET0045 2.2k
R18 /NET0032 /NET0045 16.9k
C9 0 +3V3 100n
C11 0 +3V3 10u
C6 /0ISOEC /NET0005 100n
C10 /0ISOEC /NET0005 10u
C54 0 +5V 10u
R48 8BK +5V 52.3k
R32 0 8BK 10k
C1 +5V 0 220u
C38 0 +5V 10u
C72 0 +5V 10u
C60 0 +3V3 22u
C49 /NET0099 /0ISOpH 100n
C41 /0ISOpH /NET0088 10u
R14 /NET0018 /NET0099 2.2k
R20 /NET0069 /NET0099 2.2k
C26 0 +3V3 100n
C83 0 +3V3 10u
R30 /NET0032 /0ISOEC 10k
C62 0 +3V3 10u
C15 +3V3 0 10n
C68 0 +3V3 100n
C47 +3V3 0 100n
L2 /+5VBK +5V 10u
C13 /NET0075 /+5VBK 100n
C34 0 /NET0078 33n
R22 0 /NET0067 21k
R1 /NET0093 /0ISOpH 10k
R7 /NET0093 /NET0099 16.9k
C40 /NET0099 /0ISOpH 10n
C88 /0ISOpH /NET0088 100n
C64 +3V3 0 100n
C94 +3V3 0 10n
C70 0 +3V3 100n
C17 0 +3V3 10u
C27 0 NA 2.2u
R26 0 /VREFNA 10.7k
R16 /VREFNA NA 14k
C85 0 +24V 100n
C35 0 +24V 100n
C73 /NET0095 +24V 100n
C86 /NET0051 /NET0087 22n
C8 0 +3V3 100n
R8 /NET0031 0 110m
R11 /NET0060 0 110m
R55 /VREFNB NB 14k
C79 0 NB 2.2u
R23 0 /VREFNB 10.7k
R56 /NET0077 0 110m
R43 /NET0042 0 110m

V_24V +24V 0 DC 24.0
V_3V3 +3V3 0 DC 3.3
V_5V +5V 0 DC 5.0

.control
tran 100u 10m
set filetype=ascii
write OPNhydro_r2_raw.raw all
.endc

.end
