.title KiCad schematic

C30 0 +24V 100n
C93 0 +3V3 10u
C24 0 +3V3 100n
C67 NET0069 +3V3 100n
R22 NET0024 +3V3 10k
R40 0 NET0069 10k
C18 0 NET0024 100n
C21 +5V 0 100u
R54 NET0016 /NET0042 100
R46 0 /NET0042 10k
C13 0 +24V 100n
C69 +24V 0 47u
R48 NET0024 /NET0059 4.7k
R30 NET0069 /NET0054 4.7k
R52 NET0003 /NET0048 100
C72 +24V 0 220u
R3 /NET0048 +3V3 10k
C33 0 +3V3 100n
C48 /NET0089 /NET0040 22n
C53 0 pH 2.2u
C52 0 +3V3 100n
C15 +24V 0 220u
R8 0 /VREFpH 10.7k
R12 /VREFpH pH 14k
C62 /NET0086 +24V 100n
C8 /NET0062 /NET0050 22n
C73 0 +24V 100n
C70 0 +24V 100n
R1 /NET0097 0 110m
R16 /NET0001 0 110m
C47 0 +24V 100n
C22 /NET0012 +24V 100n
C23 0 +24V 100n
C9 +24V 0 220u
C38 +24V 0 220u
C86 +24V 0 1000u
R25 /NET0072 /+24VF 33k
C12 0 +24V 10u
C6 0 +24V 100n
R24 NET0039 +3V3 2.2k
R10 NET0009 +3V3 2.2k
R55 Net-_M4A-TX1/IO22_ NET0087 1k
C64 /NET0033 /0ISOEC 10n
C85 /NET0033 /0ISOEC 100n
R14 /NET0064 /NET0033 2.2k
R2 /NET0091 /NET0033 2.2k
R6 /NET0028 /NET0033 16.9k
C34 0 +3V3 100n
C39 0 +3V3 10u
C77 /0ISOEC /NET0049 100n
C61 /0ISOEC /NET0049 10u
C94 0 +5V 10u
R45 8BK +5V 52.3k
R9 0 8BK 10k
C71 +5V 0 220u
C66 0 +5V 10u
C96 0 +5V 10u
C37 0 +3V3 22u
C27 /NET0067 /0ISOpH 100n
C49 /0ISOpH /NET0020 10u
R51 /NET0093 /NET0067 2.2k
R26 /NET0014 /NET0067 2.2k
C4 0 +3V3 100n
C90 0 +3V3 10u
R33 /NET0028 /0ISOEC 10k
C89 0 +3V3 10u
C31 +3V3 0 10n
C50 0 +3V3 100n
C7 +3V3 0 100n
L2 /+5VBK +5V 10u
C78 /NET0061 /+5VBK 100n
C87 0 /NET0083 33n
R42 0 /NET0082 21k
R44 /NET0025 /0ISOpH 10k
R39 /NET0025 /NET0067 16.9k
C19 /NET0067 /0ISOpH 10n
C88 /0ISOpH /NET0020 100n
C20 +3V3 0 100n
C3 +3V3 0 10n
C65 0 +3V3 100n
C26 0 +3V3 10u
C83 0 NA 2.2u
R31 0 /VREFNA 10.7k
R5 /VREFNA NA 14k
C79 0 +24V 100n
C80 0 +24V 100n
C10 /NET0015 +24V 100n
C92 /NET0081 /NET0080 22n
C56 0 +3V3 100n
R17 /NET0094 0 110m
R37 /NET0006 0 110m
R23 /VREFNB NB 14k
C14 0 NB 2.2u
R18 0 /VREFNB 10.7k
R47 /NET0047 0 110m
R11 /NET0057 0 110m

V_24V +24V 0 DC 24.0
V_3V3 +3V3 0 DC 3.3
V_5V +5V 0 DC 5.0

.control
tran 100u 10m
set filetype=ascii
write OPNhydro_r2_raw.raw all
.endc

.end
