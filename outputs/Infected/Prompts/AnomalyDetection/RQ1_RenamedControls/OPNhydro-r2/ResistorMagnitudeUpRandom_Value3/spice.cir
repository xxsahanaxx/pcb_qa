.title KiCad schematic

C25 0 +24V 100n
C75 0 +3V3 10u
C26 0 +3V3 100n
C80 NET0032 +3V3 100n
R5 NET0096 +3V3 10k
R43 0 NET0032 10k
C69 0 NET0096 100n
C3 +5V 0 100u
R45 NET0004 /NET0026 100
R30 0 /NET0026 10k
C29 0 +24V 100n
C2 +24V 0 47u
R34 NET0096 /NET0066 4.7k
R1 NET0032 /NET0063 4.7k
R55 NET0098 /NET0011 100
C61 +24V 0 220u
R15 /NET0011 +3V3 10k
C49 0 +3V3 100n
C70 /NET0019 /NET0057 22n
C90 0 pH 2.2u
C39 0 +3V3 100n
C32 +24V 0 220u
R44 0 /VREFpH 10.7k
R40 /VREFpH pH 14k
C18 /NET0028 +24V 100n
C37 /NET0043 /NET0039 22n
C83 0 +24V 100n
C4 0 +24V 100n
R9 /NET0033 0 110m
R17 /NET0089 0 110m
C47 0 +24V 100n
C73 /NET0062 +24V 100n
C42 0 +24V 100n
C35 +24V 0 220u
C68 +24V 0 220u
C11 +24V 0 1000u
R20 /NET0072 /+24VF 33k
C87 0 +24V 10u
C21 0 +24V 100n
R47 NET0007 +3V3 2.2k
R56 NET0036 +3V3 2.2k
R31 Net-_M4A-TX1/IO22_ NET0041 1k
C56 /NET0052 /0ISOEC 10n
C66 /NET0052 /0ISOEC 100n
R21 /NET0051 /NET0052 2.2k
R46 /NET0083 /NET0052 2.2k
R37 /NET0067 /NET0052 16.9k
C72 0 +3V3 100n
C31 0 +3V3 10u
C92 /0ISOEC /NET0025 100n
C58 /0ISOEC /NET0025 10u
C54 0 +5V 10u
R24 8BK +5V 52.3k
R8 0 8BK 10k
C77 +5V 0 220u
C60 0 +5V 10u
C65 0 +5V 10u
C5 0 +3V3 22u
C45 /NET0075 /0ISOpH 100n
C81 /0ISOpH /NET0087 10u
R23 /NET0095 /NET0075 2.2k
R48 /NET0014 /NET0075 2.2k
C89 0 +3V3 100n
C59 0 +3V3 10u
R14 /NET0067 /0ISOEC 10k
C85 0 +3V3 10u
C15 +3V3 0 10n
C30 0 +3V3 100n
C12 +3V3 0 100n
L2 /+5VBK +5V 10u
C14 /NET0078 /+5VBK 100n
C41 0 /NET0080 33n
R7 0 /NET0061 21k
R12 /NET0002 /0ISOpH 10k
R29 /NET0002 /NET0075 16.9k
C48 /NET0075 /0ISOpH 10n
C36 /0ISOpH /NET0087 100n
C88 +3V3 0 100n
C23 +3V3 0 10n
C86 0 +3V3 100n
C22 0 +3V3 10u
C94 0 NA 2.2u
R38 0 /VREFNA 10.7k
R10 /VREFNA NA 14k
C64 0 +24V 100n
C55 0 +24V 100n
C63 /NET0093 +24V 100n
C84 /NET0008 /NET0088 22n
C53 0 +3V3 100n
R28 /NET0086 0 110m
R3 /NET0091 0 110m
R25 /VREFNB NB 14k
C28 0 NB 2.2u
R36 0 /VREFNB 10.7k
R41 /NET0053 0 110m
R54 /NET0010 0 110m

V_24V +24V 0 DC 24.0
V_3V3 +3V3 0 DC 3.3
V_5V +5V 0 DC 5.0

.control
tran 100u 10m
set filetype=ascii
write OPNhydro_r2_raw.raw all
.endc

.end
