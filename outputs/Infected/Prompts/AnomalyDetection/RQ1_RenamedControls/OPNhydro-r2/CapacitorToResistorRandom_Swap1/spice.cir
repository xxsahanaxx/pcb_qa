.title KiCad schematic

C71 0 +24V 100n
C39 0 +3V3 10u
C25 0 +3V3 100n
C45 NET0061 +3V3 100n
R29 NET0049 +3V3 10k
R48 0 NET0061 10k
C55 0 NET0049 100n
C50 +5V 0 100u
R41 NET0043 /NET0037 100
R51 0 /NET0037 10k
C92 0 +24V 100n
C70 +24V 0 47u
R32 NET0049 /NET0014 4.7k
R14 NET0061 /NET0036 4.7k
R9 NET0058 /NET0078 100
C68 +24V 0 220u
R35 /NET0078 +3V3 10k
C73 0 +3V3 100n
C8 /NET0040 /NET0032 22n
C83 0 pH 2.2u
C63 0 +3V3 100n
C87 +24V 0 220u
R19 0 /VREFpH 10.7k
R44 /VREFpH pH 14k
C2 /NET0028 +24V 100n
C59 /NET0047 /NET0085 22n
C38 0 +24V 100n
C64 0 +24V 100n
R12 /NET0017 0 110m
R20 /NET0071 0 110m
C29 0 +24V 100n
C54 /NET0041 +24V 100n
C88 0 +24V 100n
C84 +24V 0 220u
C90 +24V 0 220u
C24 +24V 0 1000u
R30 /NET0092 /+24VF 33k
C42 0 +24V 10u
C13 0 +24V 100n
R50 NET0001 +3V3 2.2k
R17 NET0015 +3V3 2.2k
R21 Net-_M5A-TX1/IO22_ NET0098 1k
C47 /NET0003 /0ISOEC 10n
C1 /NET0003 /0ISOEC 100n
R18 /NET0056 /NET0003 2.2k
R34 /NET0079 /NET0003 2.2k
R53 /NET0046 /NET0003 16.9k
C12 0 +3V3 100n
C96 0 +3V3 10u
C27 /0ISOEC /NET0045 100n
C94 /0ISOEC /NET0045 10u
C81 0 +5V 10u
R37 8BK +5V 52.3k
R26 0 8BK 10k
C16 +5V 0 220u
C40 0 +5V 10u
C89 0 +5V 10u
C86 0 +3V3 22u
C19 /NET0059 /0ISOpH 100n
C49 /0ISOpH /NET0073 10u
R4 /NET0044 /NET0059 2.2k
R11 /NET0050 /NET0059 2.2k
C17 0 +3V3 100n
C9 0 +3V3 10u
R16 /NET0046 /0ISOEC 10k
C20 0 +3V3 10u
C18 +3V3 0 10n
C79 0 +3V3 100n
C72 +3V3 0 100n
L2 /+5VBK +5V 10u
C60 /NET0099 /+5VBK 100n
C15 0 /NET0034 33n
R1 0 /NET0086 21k
R56 /NET0080 /0ISOpH 10k
R5 /NET0080 /NET0059 16.9k
C53 /NET0059 /0ISOpH 10n
C56 /0ISOpH /NET0073 100n
C58 +3V3 0 100n
C4 +3V3 0 10n
C28 0 +3V3 100n
C32 0 +3V3 10u
C44 0 NA 2.2u
R39 0 /VREFNA 10.7k
R8 /VREFNA NA 14k
C43 0 +24V 100n
C76 0 +24V 100n
C23 /NET0006 +24V 100n
C85 /NET0055 /NET0031 22n
C74 0 +3V3 100n
R43 /NET0042 0 110m
R27 /NET0052 0 110m
R6 /VREFNB NB 14k
C34 0 NB 2.2u
R22 0 /VREFNB 10.7k
R10 /NET0051 0 110m
R24 /NET0016 0 110m

V_24V +24V 0 DC 24.0
V_3V3 +3V3 0 DC 3.3
V_5V +5V 0 DC 5.0

.control
tran 100u 10m
set filetype=ascii
write OPNhydro_r2_raw.raw all
.endc

.end
