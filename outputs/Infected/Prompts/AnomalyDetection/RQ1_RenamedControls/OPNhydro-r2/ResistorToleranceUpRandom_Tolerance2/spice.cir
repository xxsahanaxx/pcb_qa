.title KiCad schematic

C14 0 +24V 100n
C83 0 +3V3 10u
C35 0 +3V3 100n
C19 NET0039 +3V3 100n
R12 NET0058 +3V3 10k
R27 0 NET0039 10k
C91 0 NET0058 100n
C27 +5V 0 100u
R48 NET0083 /NET0015 100
R11 0 /NET0015 10k
C89 0 +24V 100n
C16 +24V 0 47u
R8 NET0058 /NET0017 4.7k
R40 NET0039 /NET0059 4.7k
R4 NET0049 /NET0092 100
C17 +24V 0 220u
R33 /NET0092 +3V3 10k
C10 0 +3V3 100n
C32 /NET0045 /NET0042 22n
C80 0 pH 2.2u
C61 0 +3V3 100n
C69 +24V 0 220u
R29 0 /VREFpH 10.7k
R53 /VREFpH pH 14k
C44 /NET0004 +24V 100n
C11 /NET0038 /NET0033 22n
C37 0 +24V 100n
C79 0 +24V 100n
R10 /NET0002 0 110m
R34 /NET0019 0 110m
C66 0 +24V 100n
C53 /NET0099 +24V 100n
C8 0 +24V 100n
C42 +24V 0 220u
C6 +24V 0 220u
C55 +24V 0 1000u
R22 /NET0095 /+24VF 33k
C54 0 +24V 10u
C86 0 +24V 100n
R28 NET0073 +3V3 2.2k
R23 NET0081 +3V3 2.2k
R20 Net-_M6A-TX1/IO22_ NET0057 1k
C51 /NET0048 /0ISOEC 10n
C5 /NET0048 /0ISOEC 100n
R1 /NET0063 /NET0048 2.2k
R2 /NET0032 /NET0048 2.2k
R37 /NET0008 /NET0048 16.9k
C52 0 +3V3 100n
C57 0 +3V3 10u
C38 /0ISOEC /NET0079 100n
C85 /0ISOEC /NET0079 10u
C34 0 +5V 10u
R54 8BK +5V 52.3k
R21 0 8BK 10k
C1 +5V 0 220u
C43 0 +5V 10u
C30 0 +5V 10u
C74 0 +3V3 22u
C87 /NET0090 /0ISOpH 100n
C47 /0ISOpH /NET0084 10u
R35 /NET0093 /NET0090 2.2k
R56 /NET0056 /NET0090 2.2k
C92 0 +3V3 100n
C48 0 +3V3 10u
R30 /NET0008 /0ISOEC 10k
C24 0 +3V3 10u
C22 +3V3 0 10n
C7 0 +3V3 100n
C81 +3V3 0 100n
L2 /+5VBK +5V 10u
C60 /NET0026 /+5VBK 100n
C88 0 /NET0014 33n
R50 0 /NET0068 21k
R36 /NET0037 /0ISOpH 10k
R42 /NET0037 /NET0090 16.9k
C94 /NET0090 /0ISOpH 10n
C71 /0ISOpH /NET0084 100n
C75 +3V3 0 100n
C77 +3V3 0 10n
C13 0 +3V3 100n
C67 0 +3V3 10u
C15 0 NA 2.2u
R5 0 /VREFNA 10.7k
R18 /VREFNA NA 14k
C20 0 +24V 100n
C72 0 +24V 100n
C50 /NET0094 +24V 100n
C41 /NET0087 /NET0005 22n
C33 0 +3V3 100n
R14 /NET0031 0 110m
R19 /NET0096 0 110m
R31 /VREFNB NB 14k
C59 0 NB 2.2u
R17 0 /VREFNB 10.7k
R43 /NET0009 0 110m
R44 /NET0054 0 110m

V_24V +24V 0 DC 24.0
V_3V3 +3V3 0 DC 3.3
V_5V +5V 0 DC 5.0

.control
tran 100u 10m
set filetype=ascii
write OPNhydro_r2_raw.raw all
.endc

.end
