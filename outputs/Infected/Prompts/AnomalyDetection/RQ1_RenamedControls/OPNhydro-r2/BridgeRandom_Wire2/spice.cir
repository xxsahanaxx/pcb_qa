.title KiCad schematic

C51 0 +24V 100n
C18 0 +3V3 10u
C15 0 +3V3 100n
C92 NET0057 +3V3 100n
R18 NET0041 +3V3 10k
R53 0 NET0057 10k
C91 0 NET0041 100n
C77 +5V 0 100u
R9 NET0005 /NET0033 100
R50 0 /NET0033 10k
C57 0 +24V 100n
C31 +24V 0 47u
R10 NET0041 /NET0066 4.7k
R56 NET0057 /NET0011 4.7k
R21 NET0063 /NET0025 100
C80 +24V 0 220u
R3 /NET0025 +3V3 10k
C79 0 +3V3 100n
C38 /NET0006 /NET0060 22n
C85 0 pH 2.2u
C23 0 +3V3 100n
C73 +24V 0 220u
R24 0 /VREFpH 10.7k
R35 /VREFpH pH 14k
C86 /NET0044 +24V 100n
C12 /NET0078 /NET0065 22n
C90 0 +24V 100n
C41 0 +24V 100n
R12 /NET0088 0 110m
R51 /NET0016 0 110m
C59 0 +24V 100n
C13 /NET0082 +24V 100n
C52 0 +24V 100n
C81 +24V 0 220u
C67 +24V 0 220u
C4 +24V 0 1000u
R17 /NET0056 /+24VF 33k
C30 0 +24V 10u
C28 0 +24V 100n
R1 NET0028 +3V3 2.2k
R38 NET0055 +3V3 2.2k
R52 Net-_M4A-TX1/IO22_ NET0093 1k
C24 /NET0050 /0ISOEC 10n
C32 /NET0050 /0ISOEC 100n
R7 /NET0030 /NET0050 2.2k
R40 /NET0007 /NET0050 2.2k
R8 /NET0074 /NET0050 16.9k
C50 0 +3V3 100n
C63 0 +3V3 10u
C29 /0ISOEC /NET0014 100n
C3 /0ISOEC /NET0014 10u
C55 0 +5V 10u
R22 8BK +5V 52.3k
R41 0 8BK 10k
C93 +5V 0 220u
C37 0 +5V 10u
C46 0 +5V 10u
C65 0 +3V3 22u
C53 /NET0080 /0ISOpH 100n
C64 /0ISOpH /NET0075 10u
R30 /NET0037 /NET0080 2.2k
R36 /NET0003 /NET0080 2.2k
C84 0 +3V3 100n
C45 0 +3V3 10u
R43 /NET0074 /0ISOEC 10k
C71 0 +3V3 10u
C70 +3V3 0 10n
C83 0 +3V3 100n
C6 +3V3 0 100n
L2 /+5VBK +5V 10u
C89 /NET0070 /+5VBK 100n
C17 0 /NET0089 33n
R32 0 /NET0024 21k
R28 /NET0049 /0ISOpH 10k
R15 /NET0049 /NET0080 16.9k
C66 /NET0080 /0ISOpH 10n
C72 /0ISOpH /NET0075 100n
C25 +3V3 0 100n
C35 +3V3 0 10n
C16 0 +3V3 100n
C96 0 +3V3 10u
C95 0 NA 2.2u
R26 0 /VREFNA 10.7k
R4 /VREFNA NA 14k
C75 0 +24V 100n
C39 0 +24V 100n
C42 /NET0035 +24V 100n
C87 /NET0096 /NET0090 22n
C19 0 +3V3 100n
R37 /NET0031 0 110m
R42 /NET0097 0 110m
R39 /VREFNB NB 14k
C88 0 NB 2.2u
R2 0 /VREFNB 10.7k
R48 /NET0004 0 110m
R23 /NET0061 0 110m

V_24V +24V 0 DC 24.0
V_3V3 +3V3 0 DC 3.3
V_5V +5V 0 DC 5.0

.control
tran 100u 10m
set filetype=ascii
write OPNhydro_r2_raw.raw all
.endc

.end
