.title KiCad schematic

C34 0 +24V 100n
C5 0 +3V3 10u
C83 0 +3V3 100n
C89 NET0071 +3V3 100n
R47 NET0008 +3V3 10k
R29 0 NET0071 10k
C62 0 NET0008 100n
C27 +5V 0 100u
R51 NET0055 /NET0047 100
R33 0 /NET0047 10k
C64 0 +24V 100n
C60 +24V 0 47u
R50 NET0008 /NET0079 4.7k
R54 NET0071 /NET0002 4.7k
R18 NET0024 /NET0044 100
C54 +24V 0 220u
R40 /NET0044 +3V3 10k
C84 0 +3V3 100n
C82 /NET0095 /NET0021 22n
C37 0 pH 2.2u
C93 0 +3V3 100n
C1 +24V 0 220u
R45 0 /VREFpH 10.7k
R12 /VREFpH pH 14k
C46 /NET0093 +24V 100n
C96 /NET0023 /NET0037 22n
C55 0 +24V 100n
C79 0 +24V 100n
R3 /NET0070 0 110m
R2 /NET0011 0 110m
C20 0 +24V 100n
C31 /NET0001 +24V 100n
C23 0 +24V 100n
C22 +24V 0 220u
C11 +24V 0 220u
C70 +24V 0 1000u
R8 /NET0017 /+24VF 33k
C18 0 +24V 10u
C21 0 +24V 100n
R37 NET0097 +3V3 2.2k
R56 NET0061 +3V3 2.2k
R46 Net-_M6A-TX1/IO22_ NET0085 1k
C87 /NET0064 /0ISOEC 10n
C33 /NET0064 /0ISOEC 100n
R9 /NET0041 /NET0064 2.2k
R15 /NET0035 /NET0064 2.2k
R11 /NET0022 /NET0064 16.9k
C77 0 +3V3 100n
C86 0 +3V3 10u
C72 /0ISOEC /NET0066 100n
C17 /0ISOEC /NET0066 10u
C30 0 +5V 10u
R36 8BK +5V 52.3k
R55 0 8BK 10k
C9 +5V 0 220u
C88 0 +5V 10u
C13 0 +5V 10u
C15 0 +3V3 22u
C26 /NET0083 /0ISOpH 100n
C51 /0ISOpH /NET0056 10u
R14 /NET0053 /NET0083 2.2k
R10 /NET0082 /NET0083 2.2k
C38 0 +3V3 100n
C6 0 +3V3 10u
R16 /NET0022 /0ISOEC 10k
C61 0 +3V3 10u
C50 +3V3 0 10n
C90 0 +3V3 100n
C85 +3V3 0 100n
L2 /+5VBK +5V 10u
C73 /NET0092 /+5VBK 100n
C39 0 /NET0068 33n
R28 0 /NET0043 21k
R25 /NET0077 /0ISOpH 10k
R4 /NET0077 /NET0083 16.9k
C2 /NET0083 /0ISOpH 10n
C42 /0ISOpH /NET0056 100n
C69 +3V3 0 100n
C24 +3V3 0 10n
C94 0 +3V3 100n
C47 0 +3V3 10u
C66 0 NA 2.2u
R23 0 /VREFNA 10.7k
R1 /VREFNA NA 14k
C45 0 +24V 100n
C71 0 +24V 100n
C35 /NET0013 +24V 100n
C28 /NET0058 /NET0031 22n
C92 0 +3V3 100n
R20 /NET0096 0 110m
R27 /NET0040 0 110m
R30 /VREFNB NB 14k
C58 0 NB 2.2u
R42 0 /VREFNB 10.7k
R34 /NET0034 0 110m
R21 /NET0067 0 110m

V_24V +24V 0 DC 24.0
V_3V3 +3V3 0 DC 3.3
V_5V +5V 0 DC 5.0

.control
tran 100u 10m
set filetype=ascii
write OPNhydro_r2_raw.raw all
.endc

.end
