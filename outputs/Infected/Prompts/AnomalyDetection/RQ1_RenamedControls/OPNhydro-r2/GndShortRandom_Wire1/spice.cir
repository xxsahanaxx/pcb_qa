.title KiCad schematic

C44 0 +24V 100n
C27 0 +3V3 10u
C53 0 +3V3 100n
C52 NET0038 +3V3 100n
R37 NET0021 +3V3 10k
R25 0 NET0038 10k
C94 0 NET0021 100n
C35 +5V 0 100u
R38 NET0072 /NET0099 100
R21 0 /NET0099 10k
C55 0 +24V 100n
C81 +24V 0 47u
R33 NET0021 /NET0083 4.7k
R55 NET0038 /NET0013 4.7k
R11 NET0056 /NET0003 100
C11 +24V 0 220u
R22 /NET0003 +3V3 10k
C14 0 +3V3 100n
C7 /NET0001 /NET0050 22n
C1 0 pH 2.2u
C8 0 +3V3 100n
C17 +24V 0 220u
R27 0 /VREFpH 10.7k
R46 /VREFpH pH 14k
C85 /NET0039 +24V 100n
C62 /NET0091 /NET0030 22n
C39 0 +24V 100n
C86 0 +24V 100n
R44 /NET0070 0 110m
R29 /NET0031 0 110m
C41 0 +24V 100n
C28 /NET0065 +24V 100n
C74 0 +24V 100n
C12 +24V 0 220u
C2 +24V 0 220u
C80 +24V 0 1000u
R50 /NET0005 /+24VF 33k
C59 0 +24V 10u
C15 0 +24V 100n
R17 NET0010 +3V3 2.2k
R43 NET0074 +3V3 2.2k
R18 Net-_M5A-TX1/IO22_ NET0094 1k
C6 /NET0032 /0ISOEC 10n
C68 /NET0032 /0ISOEC 100n
R54 /NET0020 /NET0032 2.2k
R48 /NET0002 /NET0032 2.2k
R49 /NET0052 /NET0032 16.9k
C49 0 +3V3 100n
C21 0 +3V3 10u
C5 /0ISOEC /NET0055 100n
C54 /0ISOEC /NET0055 10u
C24 0 +5V 10u
R47 8BK +5V 52.3k
R10 0 8BK 10k
C75 +5V 0 220u
C29 0 +5V 10u
C83 0 +5V 10u
C23 0 +3V3 22u
C47 /NET0041 /0ISOpH 100n
C18 /0ISOpH /NET0060 10u
R39 /NET0022 /NET0041 2.2k
R19 /NET0071 /NET0041 2.2k
C76 0 +3V3 100n
C43 0 +3V3 10u
R26 /NET0052 /0ISOEC 10k
C4 0 +3V3 10u
C25 +3V3 0 10n
C40 0 +3V3 100n
C72 +3V3 0 100n
L2 /+5VBK +5V 10u
C51 /NET0077 /+5VBK 100n
C78 0 /NET0062 33n
R30 0 /NET0095 21k
R12 /NET0097 /0ISOpH 10k
R34 /NET0097 /NET0041 16.9k
C3 /NET0041 /0ISOpH 10n
C37 /0ISOpH /NET0060 100n
C67 +3V3 0 100n
C57 +3V3 0 10n
C34 0 +3V3 100n
C93 0 +3V3 10u
C56 0 NA 2.2u
R9 0 /VREFNA 10.7k
R40 /VREFNA NA 14k
C64 0 +24V 100n
C50 0 +24V 100n
C60 /NET0064 +24V 100n
C36 /NET0078 /NET0061 22n
C22 0 +3V3 100n
R31 /NET0068 0 110m
R4 /NET0079 0 110m
R56 /VREFNB NB 14k
C82 0 NB 2.2u
R32 0 /VREFNB 10.7k
R7 /NET0026 0 110m
R1 /NET0028 0 110m

V_24V +24V 0 DC 24.0
V_3V3 +3V3 0 DC 3.3
V_5V +5V 0 DC 5.0

.control
tran 100u 10m
set filetype=ascii
write OPNhydro_r2_raw.raw all
.endc

.end
