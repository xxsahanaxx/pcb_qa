.title KiCad schematic

C74 0 +24V 100n
C63 0 +3V3 10u
C19 0 +3V3 100n
C40 NET0021 +3V3 100n
R52 NET0056 +3V3 10k
R56 0 NET0021 10k
C59 0 NET0056 100n
C37 +5V 0 100u
R54 NET0045 /NET0060 100
R30 0 /NET0060 10k
C65 0 +24V 100n
C44 +24V 0 47u
R27 NET0056 /NET0054 4.7k
R32 NET0021 /NET0087 4.7k
R16 NET0083 /NET0098 100
C1 +24V 0 220u
R46 /NET0098 +3V3 10k
C91 0 +3V3 100n
C46 /NET0082 /NET0007 22n
C50 0 pH 2.2u
C84 0 +3V3 100n
C85 +24V 0 220u
R55 0 /VREFpH 10.7k
R50 /VREFpH pH 14k
C54 /NET0078 +24V 100n
C57 /NET0055 /NET0049 22n
C94 0 +24V 100n
C33 0 +24V 100n
R28 /NET0026 0 110m
R43 /NET0028 0 110m
C28 0 +24V 100n
C42 /NET0039 +24V 100n
C62 0 +24V 100n
C48 +24V 0 220u
C75 +24V 0 220u
C71 +24V 0 1000u
R4 /NET0014 /+24VF 33k
C31 0 +24V 10u
C25 0 +24V 100n
R1 NET0071 +3V3 2.2k
R22 NET0095 +3V3 2.2k
R5 Net-_M6A-TX1/IO22_ NET0057 1k
C87 /NET0033 /0ISOEC 10n
C76 /NET0033 /0ISOEC 100n
R31 /NET0079 /NET0033 2.2k
R12 /NET0059 /NET0033 2.2k
R41 /NET0015 /NET0033 16.9k
C52 0 +3V3 100n
C27 0 +3V3 10u
C78 /0ISOEC /NET0023 100n
C8 /0ISOEC /NET0023 10u
C5 0 +5V 10u
R51 8BK +5V 52.3k
R36 0 8BK 10k
C18 +5V 0 220u
C88 0 +5V 10u
C41 0 +5V 10u
C17 0 +3V3 22u
C96 /NET0073 /0ISOpH 100n
C11 /0ISOpH /NET0066 10u
R48 /NET0052 /NET0073 2.2k
R26 /NET0027 /NET0073 2.2k
C39 0 +3V3 100n
C66 0 +3V3 10u
R42 /NET0015 /0ISOEC 10k
C60 0 +3V3 10u
C7 +3V3 0 10n
C49 0 +3V3 100n
C24 +3V3 0 100n
L2 /+5VBK +5V 10u
C77 /NET0064 /+5VBK 100n
C70 0 /NET0051 33n
R17 0 /NET0002 21k
R18 /NET0075 /0ISOpH 10k
R33 /NET0075 /NET0073 16.9k
C81 /NET0073 /0ISOpH 10n
C56 /0ISOpH /NET0066 100n
C20 +3V3 0 100n
C2 +3V3 0 10n
C15 0 +3V3 100n
C53 0 +3V3 10u
C35 0 NA 2.2u
R34 0 /VREFNA 10.7k
R3 /VREFNA NA 14k
C38 0 +24V 100n
C67 0 +24V 100n
C34 /NET0032 +24V 100n
C3 /NET0077 /NET0043 22n
C36 0 +3V3 100n
R13 /NET0011 0 110m
R7 /NET0017 0 110m
R11 /VREFNB NB 14k
C12 0 NB 2.2u
R45 0 /VREFNB 10.7k
R14 /NET0001 0 110m
R21 /NET0070 0 110m

V_24V +24V 0 DC 24.0
V_3V3 +3V3 0 DC 3.3
V_5V +5V 0 DC 5.0

.control
tran 100u 10m
set filetype=ascii
write OPNhydro_r2_raw.raw all
.endc

.end
