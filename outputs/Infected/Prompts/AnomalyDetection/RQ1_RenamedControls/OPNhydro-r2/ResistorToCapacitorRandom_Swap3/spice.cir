.title KiCad schematic

C76 0 +24V 100n
C58 0 +3V3 10u
C19 0 +3V3 100n
C94 NET0021 +3V3 100n
R56 NET0050 +3V3 10k
R23 0 NET0021 10k
C33 0 NET0050 100n
C45 +5V 0 100u
R32 NET0063 /NET0056 100
R5 0 /NET0056 10k
C10 0 +24V 100n
C86 +24V 0 47u
R29 NET0050 /NET0014 4.7k
R10 NET0021 /NET0061 4.7k
R34 NET0018 /NET0044 100
C24 +24V 0 220u
R48 /NET0044 +3V3 10k
C72 0 +3V3 100n
C62 /NET0049 /NET0090 22n
C78 0 pH 2.2u
C46 0 +3V3 100n
C49 +24V 0 220u
R41 0 /VREFpH 10.7k
R17 /VREFpH pH 14k
C12 /NET0008 +24V 100n
C13 /NET0040 /NET0068 22n
C60 0 +24V 100n
C4 0 +24V 100n
R45 /NET0096 0 110m
R46 /NET0067 0 110m
C7 0 +24V 100n
C85 /NET0038 +24V 100n
C47 0 +24V 100n
C30 +24V 0 220u
C83 +24V 0 220u
C61 +24V 0 1000u
R47 /NET0024 /+24VF 33k
C73 0 +24V 10u
C21 0 +24V 100n
R15 NET0055 +3V3 2.2k
R28 NET0069 +3V3 2.2k
R18 Net-_M4A-TX1/IO22_ NET0078 1k
C84 /NET0022 /0ISOEC 10n
C25 /NET0022 /0ISOEC 100n
R53 /NET0062 /NET0022 2.2k
R51 /NET0025 /NET0022 2.2k
R11 /NET0007 /NET0022 16.9k
C6 0 +3V3 100n
C57 0 +3V3 10u
C92 /0ISOEC /NET0016 100n
C29 /0ISOEC /NET0016 10u
C3 0 +5V 10u
R54 8BK +5V 52.3k
R21 0 8BK 10k
C90 +5V 0 220u
C23 0 +5V 10u
C5 0 +5V 10u
C48 0 +3V3 22u
C44 /NET0064 /0ISOpH 100n
C74 /0ISOpH /NET0013 10u
R20 /NET0099 /NET0064 2.2k
R39 /NET0092 /NET0064 2.2k
C79 0 +3V3 100n
C20 0 +3V3 10u
R31 /NET0007 /0ISOEC 10k
C9 0 +3V3 10u
C40 +3V3 0 10n
C55 0 +3V3 100n
C91 +3V3 0 100n
L2 /+5VBK +5V 10u
C37 /NET0058 /+5VBK 100n
C81 0 /NET0004 33n
R7 0 /NET0011 21k
R9 /NET0034 /0ISOpH 10k
R27 /NET0034 /NET0064 16.9k
C18 /NET0064 /0ISOpH 10n
C14 /0ISOpH /NET0013 100n
C75 +3V3 0 100n
C35 +3V3 0 10n
C51 0 +3V3 100n
C11 0 +3V3 10u
C28 0 NA 2.2u
R42 0 /VREFNA 10.7k
R38 /VREFNA NA 14k
C88 0 +24V 100n
C80 0 +24V 100n
C17 /NET0083 +24V 100n
C96 /NET0057 /NET0089 22n
C71 0 +3V3 100n
R19 /NET0001 0 110m
R6 /NET0005 0 110m
R4 /VREFNB NB 14k
C27 0 NB 2.2u
R50 0 /VREFNB 10.7k
R12 /NET0027 0 110m
R43 /NET0065 0 110m

V_24V +24V 0 DC 24.0
V_3V3 +3V3 0 DC 3.3
V_5V +5V 0 DC 5.0

.control
tran 100u 10m
set filetype=ascii
write OPNhydro_r2_raw.raw all
.endc

.end
