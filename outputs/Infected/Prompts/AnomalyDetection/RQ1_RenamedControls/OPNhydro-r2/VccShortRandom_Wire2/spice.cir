.title KiCad schematic

C55 0 +24V 100n
C59 0 +3V3 10u
C57 0 +3V3 100n
C10 NET0072 +3V3 100n
R26 NET0061 +3V3 10k
R16 0 NET0072 10k
C51 0 NET0061 100n
C68 +5V 0 100u
R8 NET0049 /NET0081 100
R1 0 /NET0081 10k
C60 0 +24V 100n
C82 +24V 0 47u
R6 NET0061 /NET0038 4.7k
R29 NET0072 /NET0064 4.7k
R31 NET0085 /NET0035 100
C11 +24V 0 220u
R4 /NET0035 +3V3 10k
C40 0 +3V3 100n
C91 /NET0037 /NET0023 22n
C17 0 pH 2.2u
C54 0 +3V3 100n
C90 +24V 0 220u
R56 0 /VREFpH 10.7k
R52 /VREFpH pH 14k
C71 /NET0092 +24V 100n
C65 /NET0012 /NET0076 22n
C12 0 +24V 100n
C85 0 +24V 100n
R48 /NET0091 0 110m
R40 /NET0031 0 110m
C22 0 +24V 100n
C43 /NET0097 +24V 100n
C38 0 +24V 100n
C92 +24V 0 220u
C69 +24V 0 220u
C46 +24V 0 1000u
R14 /NET0058 /+24VF 33k
C25 0 +24V 10u
C28 0 +24V 100n
R49 NET0007 +3V3 2.2k
R25 NET0084 +3V3 2.2k
R23 Net-_M5A-TX1/IO22_ NET0017 1k
C48 /NET0053 /0ISOEC 10n
C47 /NET0053 /0ISOEC 100n
R30 /NET0003 /NET0053 2.2k
R21 /NET0022 /NET0053 2.2k
R44 /NET0080 /NET0053 16.9k
C1 0 +3V3 100n
C62 0 +3V3 10u
C8 /0ISOEC /NET0006 100n
C78 /0ISOEC /NET0006 10u
C96 0 +5V 10u
R5 8BK +5V 52.3k
R22 0 8BK 10k
C41 +5V 0 220u
C26 0 +5V 10u
C84 0 +5V 10u
C6 0 +3V3 22u
C32 /NET0055 /0ISOpH 100n
C34 /0ISOpH /NET0073 10u
R13 /NET0071 /NET0055 2.2k
R7 /NET0020 /NET0055 2.2k
C37 0 +3V3 100n
C24 0 +3V3 10u
R2 /NET0080 /0ISOEC 10k
C31 0 +3V3 10u
C53 +3V3 0 10n
C52 0 +3V3 100n
C42 +3V3 0 100n
L2 /+5VBK +5V 10u
C9 /NET0065 /+5VBK 100n
C87 0 /NET0079 33n
R55 0 /NET0027 21k
R10 /NET0089 /0ISOpH 10k
R19 /NET0089 /NET0055 16.9k
C73 /NET0055 /0ISOpH 10n
C77 /0ISOpH /NET0073 100n
C19 +3V3 0 100n
C15 +3V3 0 10n
C27 0 +3V3 100n
C89 0 +3V3 10u
C70 0 NA 2.2u
R43 0 /VREFNA 10.7k
R33 /VREFNA NA 14k
C72 0 +24V 100n
C5 0 +24V 100n
C75 /NET0095 +24V 100n
C30 /NET0083 /NET0009 22n
C86 0 +3V3 100n
R12 /NET0086 0 110m
R53 /NET0026 0 110m
R9 /VREFNB NB 14k
C94 0 NB 2.2u
R50 0 /VREFNB 10.7k
R3 /NET0034 0 110m
R15 /NET0082 0 110m

V_24V +24V 0 DC 24.0
V_3V3 +3V3 0 DC 3.3
V_5V +5V 0 DC 5.0

.control
tran 100u 10m
set filetype=ascii
write OPNhydro_r2_raw.raw all
.endc

.end
