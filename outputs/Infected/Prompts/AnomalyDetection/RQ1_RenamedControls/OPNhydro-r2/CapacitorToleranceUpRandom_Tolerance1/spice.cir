.title KiCad schematic

C53 0 +24V 100n
C34 0 +3V3 10u
C72 0 +3V3 100n
C12 NET0028 +3V3 100n
R4 NET0077 +3V3 10k
R38 0 NET0028 10k
C83 0 NET0077 100n
C46 +5V 0 100u
R23 NET0010 /NET0015 100
R31 0 /NET0015 10k
C91 0 +24V 100n
C82 +24V 0 47u
R25 NET0077 /NET0068 4.7k
R54 NET0028 /NET0003 4.7k
R30 NET0076 /NET0029 100
C52 +24V 0 220u
R46 /NET0029 +3V3 10k
C13 0 +3V3 100n
C17 /NET0074 /NET0016 22n
C20 0 pH 2.2u
C7 0 +3V3 100n
C74 +24V 0 220u
R43 0 /VREFpH 10.7k
R34 /VREFpH pH 14k
C73 /NET0082 +24V 100n
C31 /NET0051 /NET0070 22n
C41 0 +24V 100n
C19 0 +24V 100n
R18 /NET0063 0 110m
R17 /NET0096 0 110m
C47 0 +24V 100n
C80 /NET0040 +24V 100n
C75 0 +24V 100n
C45 +24V 0 220u
C25 +24V 0 220u
C62 +24V 0 1000u
R28 /NET0067 /+24VF 33k
C16 0 +24V 10u
C1 0 +24V 100n
R50 NET0038 +3V3 2.2k
R29 NET0083 +3V3 2.2k
R26 Net-_M5A-TX1/IO22_ NET0088 1k
C71 /NET0098 /0ISOEC 10n
C40 /NET0098 /0ISOEC 100n
R10 /NET0057 /NET0098 2.2k
R27 /NET0058 /NET0098 2.2k
R2 /NET0014 /NET0098 16.9k
C54 0 +3V3 100n
C51 0 +3V3 10u
C81 /0ISOEC /NET0085 100n
C18 /0ISOEC /NET0085 10u
C69 0 +5V 10u
R15 8BK +5V 52.3k
R49 0 8BK 10k
C5 +5V 0 220u
C85 0 +5V 10u
C88 0 +5V 10u
C33 0 +3V3 22u
C86 /NET0044 /0ISOpH 100n
C55 /0ISOpH /NET0094 10u
R14 /NET0017 /NET0044 2.2k
R51 /NET0090 /NET0044 2.2k
C76 0 +3V3 100n
C36 0 +3V3 10u
R22 /NET0014 /0ISOEC 10k
C96 0 +3V3 10u
C95 +3V3 0 10n
C10 0 +3V3 100n
C4 +3V3 0 100n
L2 /+5VBK +5V 10u
C15 /NET0002 /+5VBK 100n
C26 0 /NET0013 33n
R47 0 /NET0034 21k
R7 /NET0018 /0ISOpH 10k
R3 /NET0018 /NET0044 16.9k
C2 /NET0044 /0ISOpH 10n
C67 /0ISOpH /NET0094 100n
C21 +3V3 0 100n
C87 +3V3 0 10n
C43 0 +3V3 100n
C49 0 +3V3 10u
C32 0 NA 2.2u
R42 0 /VREFNA 10.7k
R45 /VREFNA NA 14k
C79 0 +24V 100n
C57 0 +24V 100n
C23 /NET0084 +24V 100n
C90 /NET0087 /NET0025 22n
C58 0 +3V3 100n
R35 /NET0037 0 110m
R6 /NET0007 0 110m
R37 /VREFNB NB 14k
C24 0 NB 2.2u
R56 0 /VREFNB 10.7k
R19 /NET0009 0 110m
R11 /NET0064 0 110m

V_24V +24V 0 DC 24.0
V_3V3 +3V3 0 DC 3.3
V_5V +5V 0 DC 5.0

.control
tran 100u 10m
set filetype=ascii
write OPNhydro_r2_raw.raw all
.endc

.end
