.title KiCad schematic

C21 0 +24V 100n
C58 0 +3V3 10u
C14 0 +3V3 100n
C62 NET0016 +3V3 100n
R12 NET0075 +3V3 10k
R41 0 NET0016 10k
C64 0 NET0075 100n
C49 +5V 0 100u
R56 NET0036 /NET0009 100
R42 0 /NET0009 10k
C89 0 +24V 100n
C48 +24V 0 47u
R31 NET0075 /NET0067 4.7k
R25 NET0016 /NET0093 4.7k
R11 NET0030 /NET0046 100
C26 +24V 0 220u
R20 /NET0046 +3V3 10k
C81 0 +3V3 100n
C8 /NET0049 /NET0084 22n
C74 0 pH 2.2u
C18 0 +3V3 100n
C68 +24V 0 220u
R22 0 /VREFpH 10.7k
R2 /VREFpH pH 14k
C45 /NET0083 +24V 100n
C19 /NET0051 /NET0039 22n
C6 0 +24V 100n
C11 0 +24V 100n
R1 /NET0052 0 110m
R27 /NET0034 0 110m
C95 0 +24V 100n
C15 /NET0091 +24V 100n
C28 0 +24V 100n
C96 +24V 0 220u
C83 +24V 0 220u
C42 +24V 0 1000u
R33 /NET0026 /+24VF 33k
C84 0 +24V 10u
C4 0 +24V 100n
R5 NET0060 +3V3 2.2k
R9 NET0064 +3V3 2.2k
R54 Net-_M4A-TX1/IO22_ NET0087 1k
C12 /NET0079 /0ISOEC 10n
C30 /NET0079 /0ISOEC 100n
R32 /NET0017 /NET0079 2.2k
R45 /NET0029 /NET0079 2.2k
R36 /NET0043 /NET0079 16.9k
C67 0 +3V3 100n
C16 0 +3V3 10u
C87 /0ISOEC /NET0021 100n
C22 /0ISOEC /NET0021 10u
C39 0 +5V 10u
R30 8BK +5V 52.3k
R47 0 8BK 10k
C40 +5V 0 220u
C17 0 +5V 10u
C34 0 +5V 10u
C32 0 +3V3 22u
C24 /NET0081 /0ISOpH 100n
C5 /0ISOpH /NET0059 10u
R50 /NET0013 /NET0081 2.2k
R48 /NET0068 /NET0081 2.2k
C50 0 +3V3 100n
C52 0 +3V3 10u
R18 /NET0043 /0ISOEC 10k
C57 0 +3V3 10u
C65 +3V3 0 10n
C31 0 +3V3 100n
C46 +3V3 0 100n
L2 /+5VBK +5V 10u
C29 /NET0003 /+5VBK 100n
C76 0 /NET0057 33n
R24 0 /NET0022 21k
R10 /NET0041 /0ISOpH 10k
R34 /NET0041 /NET0081 16.9k
C88 /NET0081 /0ISOpH 10n
C70 /0ISOpH /NET0059 100n
C92 +3V3 0 100n
C85 +3V3 0 10n
C72 0 +3V3 100n
C71 0 +3V3 10u
C61 0 NA 2.2u
R28 0 /VREFNA 10.7k
R51 /VREFNA NA 14k
C94 0 +24V 100n
C25 0 +24V 100n
C86 /NET0033 +24V 100n
C13 /NET0092 /NET0071 22n
C33 0 +3V3 100n
R44 /NET0077 0 110m
R53 /NET0024 0 110m
R19 /VREFNB NB 14k
C90 0 NB 2.2u
R52 0 /VREFNB 10.7k
R7 /NET0099 0 110m
R8 /NET0063 0 110m

V_24V +24V 0 DC 24.0
V_3V3 +3V3 0 DC 3.3
V_5V +5V 0 DC 5.0

.control
tran 100u 10m
set filetype=ascii
write OPNhydro_r2_raw.raw all
.endc

.end
