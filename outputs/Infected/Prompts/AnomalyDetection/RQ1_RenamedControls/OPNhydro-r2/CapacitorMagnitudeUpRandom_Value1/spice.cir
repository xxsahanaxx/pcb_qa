.title KiCad schematic

C76 0 +24V 100n
C39 0 +3V3 10u
C61 0 +3V3 100n
C20 NET0025 +3V3 100n
R43 NET0021 +3V3 10k
R47 0 NET0025 10k
C60 0 NET0021 100n
C47 +5V 0 100u
R27 NET0004 /NET0007 100
R40 0 /NET0007 10k
C84 0 +24V 100n
C11 +24V 0 47u
R50 NET0021 /NET0067 4.7k
R28 NET0025 /NET0022 4.7k
R4 NET0008 /NET0043 100
C83 +24V 0 220u
R1 /NET0043 +3V3 10k
C96 0 +3V3 100n
C25 /NET0045 /NET0095 22n
C8 0 pH 2.2u
C69 0 +3V3 100n
C43 +24V 0 220u
R13 0 /VREFpH 10.7k
R38 /VREFpH pH 14k
C57 /NET0023 +24V 100n
C29 /NET0002 /NET0038 22n
C9 0 +24V 100n
C6 0 +24V 100n
R30 /NET0082 0 110m
R3 /NET0077 0 110m
C67 0 +24V 100n
C90 /NET0036 +24V 100n
C32 0 +24V 100n
C56 +24V 0 220u
C30 +24V 0 220u
C62 +24V 0 1000u
R52 /NET0062 /+24VF 33k
C50 0 +24V 10u
C21 0 +24V 100n
R24 NET0091 +3V3 2.2k
R33 NET0078 +3V3 2.2k
R15 Net-_M2A-TX1/IO22_ NET0016 1k
C18 /NET0048 /0ISOEC 10n
C77 /NET0048 /0ISOEC 100n
R25 /NET0052 /NET0048 2.2k
R21 /NET0015 /NET0048 2.2k
R5 /NET0093 /NET0048 16.9k
C92 0 +3V3 100n
C12 0 +3V3 10u
C75 /0ISOEC /NET0080 100n
C2 /0ISOEC /NET0080 10u
C5 0 +5V 10u
R31 8BK +5V 52.3k
R32 0 8BK 10k
C13 +5V 0 220u
C14 0 +5V 10u
C4 0 +5V 10u
C48 0 +3V3 22u
C86 /NET0072 /0ISOpH 100n
C31 /0ISOpH /NET0006 10u
R49 /NET0092 /NET0072 2.2k
R34 /NET0033 /NET0072 2.2k
C93 0 +3V3 100n
C66 0 +3V3 10u
R11 /NET0093 /0ISOEC 10k
C42 0 +3V3 10u
C41 +3V3 0 10n
C87 0 +3V3 100n
C95 +3V3 0 100n
L2 /+5VBK +5V 10u
C10 /NET0042 /+5VBK 100n
C65 0 /NET0057 33n
R56 0 /NET0061 21k
R18 /NET0076 /0ISOpH 10k
R53 /NET0076 /NET0072 16.9k
C85 /NET0072 /0ISOpH 10n
C78 /0ISOpH /NET0006 100n
C63 +3V3 0 100n
C80 +3V3 0 10n
C38 0 +3V3 100n
C37 0 +3V3 10u
C59 0 NA 2.2u
R41 0 /VREFNA 10.7k
R51 /VREFNA NA 14k
C72 0 +24V 100n
C81 0 +24V 100n
C23 /NET0085 +24V 100n
C1 /NET0035 /NET0026 22n
C64 0 +3V3 100n
R19 /NET0089 0 110m
R37 /NET0039 0 110m
R20 /VREFNB NB 14k
C79 0 NB 2.2u
R10 0 /VREFNB 10.7k
R22 /NET0032 0 110m
R17 /NET0086 0 110m

V_24V +24V 0 DC 24.0
V_3V3 +3V3 0 DC 3.3
V_5V +5V 0 DC 5.0

.control
tran 100u 10m
set filetype=ascii
write OPNhydro_r2_raw.raw all
.endc

.end
