.title KiCad schematic

C36 0 +24V 100n
C90 0 +3V3 10u
C27 0 +3V3 100n
C56 NET0065 +3V3 100n
R20 NET0003 +3V3 10k
R19 0 NET0065 10k
C44 0 NET0003 100n
C73 +5V 0 100u
R55 NET0088 /NET0039 100
R43 0 /NET0039 10k
C47 0 +24V 100n
C84 +24V 0 47u
R24 NET0003 /NET0002 4.7k
R10 NET0065 /NET0044 4.7k
R32 NET0074 /NET0064 100
C64 +24V 0 220u
R4 /NET0064 +3V3 10k
C65 0 +3V3 100n
C71 /NET0011 /NET0016 22n
C33 0 pH 2.2u
C81 0 +3V3 100n
C78 +24V 0 220u
R21 0 /VREFpH 10.7k
R41 /VREFpH pH 14k
C72 /NET0029 +24V 100n
C14 /NET0080 /NET0020 22n
C63 0 +24V 100n
C35 0 +24V 100n
R5 /NET0040 0 110m
R17 /NET0049 0 110m
C4 0 +24V 100n
C6 /NET0005 +24V 100n
C37 0 +24V 100n
C15 +24V 0 220u
C23 +24V 0 220u
C32 +24V 0 1000u
R49 /NET0024 /+24VF 33k
C3 0 +24V 10u
C49 0 +24V 100n
R2 NET0007 +3V3 2.2k
R47 NET0028 +3V3 2.2k
R34 Net-_M4A-TX1/IO22_ NET0056 1k
C61 /NET0081 /0ISOEC 10n
C62 /NET0081 /0ISOEC 100n
R52 /NET0014 /NET0081 2.2k
R46 /NET0042 /NET0081 2.2k
R29 /NET0091 /NET0081 16.9k
C10 0 +3V3 100n
C25 0 +3V3 10u
C30 /0ISOEC /NET0051 100n
C68 /0ISOEC /NET0051 10u
C16 0 +5V 10u
R31 8BK +5V 52.3k
R13 0 8BK 10k
C31 +5V 0 220u
C28 0 +5V 10u
C29 0 +5V 10u
C82 0 +3V3 22u
C80 /NET0079 /0ISOpH 100n
C96 /0ISOpH /NET0059 10u
R26 /NET0036 /NET0079 2.2k
R39 /NET0015 /NET0079 2.2k
C34 0 +3V3 100n
C17 0 +3V3 10u
R45 /NET0091 /0ISOEC 10k
C43 0 +3V3 10u
C58 +3V3 0 10n
C87 0 +3V3 100n
C50 +3V3 0 100n
L2 /+5VBK +5V 10u
C76 /NET0084 /+5VBK 100n
C88 0 /NET0004 33n
R18 0 /NET0086 21k
R30 /NET0034 /0ISOpH 10k
R28 /NET0034 /NET0079 16.9k
C66 /NET0079 /0ISOpH 10n
C85 /0ISOpH /NET0059 100n
C92 +3V3 0 100n
C79 +3V3 0 10n
C45 0 +3V3 100n
C7 0 +3V3 10u
C40 0 NA 2.2u
R15 0 /VREFNA 10.7k
R8 /VREFNA NA 14k
C53 0 +24V 100n
C26 0 +24V 100n
C9 /NET0096 +24V 100n
C5 /NET0072 /NET0054 22n
C67 0 +3V3 100n
R53 /NET0095 0 110m
R22 /NET0093 0 110m
R1 /VREFNB NB 14k
C54 0 NB 2.2u
R12 0 /VREFNB 10.7k
R14 /NET0008 0 110m
R23 /NET0035 0 110m

V_24V +24V 0 DC 24.0
V_3V3 +3V3 0 DC 3.3
V_5V +5V 0 DC 5.0

.control
tran 100u 10m
set filetype=ascii
write OPNhydro_r2_raw.raw all
.endc

.end
