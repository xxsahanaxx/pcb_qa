.title KiCad schematic

C71 0 +24V 100n
C24 0 +3V3 10u
C62 0 +3V3 100n
C25 NET0003 +3V3 100n
R46 NET0029 +3V3 10k
R48 0 NET0003 10k
C93 0 NET0029 100n
C55 +5V 0 100u
R17 NET0032 /NET0075 100
R25 0 /NET0075 10k
C77 0 +24V 100n
C28 +24V 0 47u
R33 NET0029 /NET0072 4.7k
R55 NET0003 /NET0086 4.7k
R28 NET0066 /NET0036 100
C21 +24V 0 220u
R35 /NET0036 +3V3 10k
C31 0 +3V3 100n
C53 /NET0037 /NET0071 22n
C89 0 pH 2.2u
C87 0 +3V3 100n
C70 +24V 0 220u
R53 0 /VREFpH 10.7k
R44 /VREFpH pH 14k
C42 /NET0099 +24V 100n
C79 /NET0025 /NET0020 22n
C29 0 +24V 100n
C11 0 +24V 100n
R50 /NET0040 0 110m
R52 /NET0008 0 110m
C38 0 +24V 100n
C72 /NET0026 +24V 100n
C8 0 +24V 100n
C19 +24V 0 220u
C22 +24V 0 220u
C33 +24V 0 1000u
R5 /NET0013 /+24VF 33k
C14 0 +24V 10u
C50 0 +24V 100n
R54 NET0006 +3V3 2.2k
R42 NET0007 +3V3 2.2k
R7 Net-_M3A-TX1/IO22_ NET0038 1k
C44 /NET0081 /0ISOEC 10n
C84 /NET0081 /0ISOEC 100n
R34 /NET0021 /NET0081 2.2k
R31 /NET0059 /NET0081 2.2k
R45 /NET0077 /NET0081 16.9k
C59 0 +3V3 100n
C91 0 +3V3 10u
C85 /0ISOEC /NET0047 100n
C60 /0ISOEC /NET0047 10u
C17 0 +5V 10u
R19 8BK +5V 52.3k
R47 0 8BK 10k
C67 +5V 0 220u
C30 0 +5V 10u
C46 0 +5V 10u
C90 0 +3V3 22u
C73 /NET0022 /0ISOpH 100n
C76 /0ISOpH /NET0016 10u
R1 /NET0076 /NET0022 2.2k
R9 /NET0048 /NET0022 2.2k
C48 0 +3V3 100n
C9 0 +3V3 10u
R11 /NET0077 /0ISOEC 10k
C56 0 +3V3 10u
C13 +3V3 0 10n
C82 0 +3V3 100n
C32 +3V3 0 100n
L2 /+5VBK +5V 10u
C45 /NET0027 /+5VBK 100n
C39 0 /NET0078 33n
R24 0 /NET0028 21k
R23 /NET0080 /0ISOpH 10k
R10 /NET0080 /NET0022 16.9k
C64 /NET0022 /0ISOpH 10n
C26 /0ISOpH /NET0016 100n
C80 +3V3 0 100n
C2 +3V3 0 10n
C41 0 +3V3 100n
C34 0 +3V3 10u
C94 0 NA 2.2u
R13 0 /VREFNA 10.7k
R43 /VREFNA NA 14k
C4 0 +24V 100n
C68 0 +24V 100n
C35 /NET0035 +24V 100n
C75 /NET0097 /NET0011 22n
C6 0 +3V3 100n
R36 /NET0060 0 110m
R6 /NET0058 0 110m
R8 /VREFNB NB 14k
C96 0 NB 2.2u
R49 0 /VREFNB 10.7k
R32 /NET0054 0 110m
R15 /NET0005 0 110m

V_24V +24V 0 DC 24.0
V_3V3 +3V3 0 DC 3.3
V_5V +5V 0 DC 5.0

.control
tran 100u 10m
set filetype=ascii
write OPNhydro_r2_raw.raw all
.endc

.end
