.title KiCad schematic

C14 0 +24V 100n
C26 0 +3V3 10u
C70 0 +3V3 100n
C78 NET0043 +3V3 100n
R38 NET0080 +3V3 10k
R41 0 NET0043 10k
C83 0 NET0080 100n
C49 +5V 0 100u
R56 NET0025 /NET0059 100
R48 0 /NET0059 10k
C79 0 +24V 100n
C31 +24V 0 47u
R3 NET0080 /NET0042 4.7k
R14 NET0043 /NET0018 4.7k
R22 NET0038 /NET0074 100
C20 +24V 0 220u
R23 /NET0074 +3V3 10k
C15 0 +3V3 100n
C21 /NET0088 /NET0020 22n
C67 0 pH 2.2u
C27 0 +3V3 100n
C57 +24V 0 220u
R54 0 /VREFpH 10.7k
R42 /VREFpH pH 14k
C16 /NET0069 +24V 100n
C45 /NET0037 /NET0056 22n
C29 0 +24V 100n
C12 0 +24V 100n
R26 /NET0061 0 110m
R43 /NET0072 0 110m
C7 0 +24V 100n
C54 /NET0048 +24V 100n
C2 0 +24V 100n
C28 +24V 0 220u
C1 +24V 0 220u
C69 +24V 0 1000u
R51 /NET0036 /+24VF 33k
C63 0 +24V 10u
C44 0 +24V 100n
R5 NET0017 +3V3 2.2k
R40 NET0035 +3V3 2.2k
R13 Net-_M6A-TX1/IO22_ NET0067 1k
C53 /NET0024 /0ISOEC 10n
C85 /NET0024 /0ISOEC 100n
R45 /NET0005 /NET0024 2.2k
R52 /NET0093 /NET0024 2.2k
R6 /NET0086 /NET0024 16.9k
C93 0 +3V3 100n
C87 0 +3V3 10u
C82 /0ISOEC /NET0034 100n
C47 /0ISOEC /NET0034 10u
C66 0 +5V 10u
R15 8BK +5V 52.3k
R31 0 8BK 10k
C64 +5V 0 220u
C42 0 +5V 10u
C39 0 +5V 10u
C84 0 +3V3 22u
C13 /NET0014 /0ISOpH 100n
C9 /0ISOpH /NET0078 10u
R7 /NET0085 /NET0014 2.2k
R24 /NET0065 /NET0014 2.2k
C30 0 +3V3 100n
C5 0 +3V3 10u
R8 /NET0086 /0ISOEC 10k
C40 0 +3V3 10u
C89 +3V3 0 10n
C76 0 +3V3 100n
C6 +3V3 0 100n
L2 /+5VBK +5V 10u
C50 /NET0003 /+5VBK 100n
C77 0 /NET0052 33n
R47 0 /NET0062 21k
R28 /NET0012 /0ISOpH 10k
R18 /NET0012 /NET0014 16.9k
C73 /NET0014 /0ISOpH 10n
C46 /0ISOpH /NET0078 100n
C92 +3V3 0 100n
C10 +3V3 0 10n
C52 0 +3V3 100n
C51 0 +3V3 10u
C74 0 NA 2.2u
R46 0 /VREFNA 10.7k
R37 /VREFNA NA 14k
C41 0 +24V 100n
C22 0 +24V 100n
C80 /NET0045 +24V 100n
C3 /NET0095 /NET0023 22n
C25 0 +3V3 100n
R36 /NET0076 0 110m
R25 /NET0001 0 110m
R17 /VREFNB NB 14k
C38 0 NB 2.2u
R49 0 /VREFNB 10.7k
R1 /NET0016 0 110m
R50 /NET0004 0 110m

V_24V +24V 0 DC 24.0
V_3V3 +3V3 0 DC 3.3
V_5V +5V 0 DC 5.0

.control
tran 100u 10m
set filetype=ascii
write OPNhydro_r2_raw.raw all
.endc

.end
