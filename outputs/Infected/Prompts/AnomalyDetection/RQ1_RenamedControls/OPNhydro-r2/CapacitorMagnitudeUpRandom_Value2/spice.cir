.title KiCad schematic

C95 0 +24V 100n
C61 0 +3V3 10u
C30 0 +3V3 100n
C12 NET0042 +3V3 100n
R18 NET0029 +3V3 10k
R26 0 NET0042 10k
C6 0 NET0029 100n
C42 +5V 0 100u
R50 NET0088 /NET0090 100
R15 0 /NET0090 10k
C3 0 +24V 100n
C48 +24V 0 47u
R10 NET0029 /NET0032 4.7k
R39 NET0042 /NET0049 4.7k
R56 NET0047 /NET0018 100
C81 +24V 0 220u
R48 /NET0018 +3V3 10k
C4 0 +3V3 100n
C59 /NET0064 /NET0007 22n
C52 0 pH 2.2u
C96 0 +3V3 100n
C66 +24V 0 220u
R46 0 /VREFpH 10.7k
R35 /VREFpH pH 14k
C46 /NET0082 +24V 100n
C80 /NET0098 /NET0037 22n
C84 0 +24V 100n
C74 0 +24V 100n
R54 /NET0038 0 110m
R33 /NET0003 0 110m
C31 0 +24V 100n
C28 /NET0080 +24V 100n
C29 0 +24V 100n
C15 +24V 0 220u
C5 +24V 0 220u
C94 +24V 0 1000u
R8 /NET0021 /+24VF 33k
C40 0 +24V 10u
C50 0 +24V 100n
R27 NET0062 +3V3 2.2k
R17 NET0008 +3V3 2.2k
R37 Net-_M4A-TX1/IO22_ NET0035 1k
C58 /NET0024 /0ISOEC 10n
C8 /NET0024 /0ISOEC 100n
R44 /NET0036 /NET0024 2.2k
R6 /NET0054 /NET0024 2.2k
R52 /NET0070 /NET0024 16.9k
C51 0 +3V3 100n
C63 0 +3V3 10u
C14 /0ISOEC /NET0086 100n
C77 /0ISOEC /NET0086 10u
C41 0 +5V 10u
R42 8BK +5V 52.3k
R14 0 8BK 10k
C24 +5V 0 220u
C45 0 +5V 10u
C2 0 +5V 10u
C55 0 +3V3 22u
C91 /NET0085 /0ISOpH 100n
C89 /0ISOpH /NET0044 10u
R36 /NET0066 /NET0085 2.2k
R40 /NET0046 /NET0085 2.2k
C27 0 +3V3 100n
C67 0 +3V3 10u
R38 /NET0070 /0ISOEC 10k
C19 0 +3V3 10u
C85 +3V3 0 10n
C90 0 +3V3 100n
C37 +3V3 0 100n
L2 /+5VBK +5V 10u
C62 /NET0048 /+5VBK 100n
C53 0 /NET0041 33n
R53 0 /NET0016 21k
R5 /NET0073 /0ISOpH 10k
R22 /NET0073 /NET0085 16.9k
C86 /NET0085 /0ISOpH 10n
C57 /0ISOpH /NET0044 100n
C10 +3V3 0 100n
C73 +3V3 0 10n
C72 0 +3V3 100n
C44 0 +3V3 10u
C88 0 NA 2.2u
R55 0 /VREFNA 10.7k
R30 /VREFNA NA 14k
C11 0 +24V 100n
C18 0 +24V 100n
C17 /NET0001 +24V 100n
C49 /NET0057 /NET0051 22n
C71 0 +3V3 100n
R51 /NET0043 0 110m
R19 /NET0050 0 110m
R23 /VREFNB NB 14k
C92 0 NB 2.2u
R45 0 /VREFNB 10.7k
R13 /NET0002 0 110m
R21 /NET0034 0 110m

V_24V +24V 0 DC 24.0
V_3V3 +3V3 0 DC 3.3
V_5V +5V 0 DC 5.0

.control
tran 100u 10m
set filetype=ascii
write OPNhydro_r2_raw.raw all
.endc

.end
