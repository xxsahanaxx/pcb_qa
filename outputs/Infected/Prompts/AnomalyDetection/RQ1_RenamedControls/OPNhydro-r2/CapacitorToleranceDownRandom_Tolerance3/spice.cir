.title KiCad schematic

C63 0 +24V 100n
C78 0 +3V3 10u
C90 0 +3V3 100n
C14 NET0030 +3V3 100n
R35 NET0075 +3V3 10k
R36 0 NET0030 10k
C42 0 NET0075 100n
C33 +5V 0 100u
R3 NET0070 /NET0080 100
R52 0 /NET0080 10k
C92 0 +24V 100n
C35 +24V 0 47u
R15 NET0075 /NET0063 4.7k
R17 NET0030 /NET0019 4.7k
R40 NET0092 /NET0069 100
C18 +24V 0 220u
R44 /NET0069 +3V3 10k
C29 0 +3V3 100n
C75 /NET0034 /NET0089 22n
C36 0 pH 2.2u
C32 0 +3V3 100n
C41 +24V 0 220u
R43 0 /VREFpH 10.7k
R19 /VREFpH pH 14k
C37 /NET0031 +24V 100n
C84 /NET0032 /NET0066 22n
C88 0 +24V 100n
C58 0 +24V 100n
R9 /NET0036 0 110m
R20 /NET0094 0 110m
C70 0 +24V 100n
C17 /NET0021 +24V 100n
C56 0 +24V 100n
C12 +24V 0 220u
C89 +24V 0 220u
C25 +24V 0 1000u
R49 /NET0061 /+24VF 33k
C48 0 +24V 10u
C27 0 +24V 100n
R47 NET0002 +3V3 2.2k
R10 NET0007 +3V3 2.2k
R24 Net-_M4A-TX1/IO22_ NET0060 1k
C93 /NET0037 /0ISOEC 10n
C46 /NET0037 /0ISOEC 100n
R27 /NET0057 /NET0037 2.2k
R29 /NET0062 /NET0037 2.2k
R1 /NET0050 /NET0037 16.9k
C19 0 +3V3 100n
C13 0 +3V3 10u
C7 /0ISOEC /NET0041 100n
C73 /0ISOEC /NET0041 10u
C11 0 +5V 10u
R18 8BK +5V 52.3k
R7 0 8BK 10k
C91 +5V 0 220u
C24 0 +5V 10u
C6 0 +5V 10u
C85 0 +3V3 22u
C80 /NET0056 /0ISOpH 100n
C55 /0ISOpH /NET0025 10u
R37 /NET0087 /NET0056 2.2k
R56 /NET0035 /NET0056 2.2k
C39 0 +3V3 100n
C96 0 +3V3 10u
R21 /NET0050 /0ISOEC 10k
C72 0 +3V3 10u
C59 +3V3 0 10n
C21 0 +3V3 100n
C71 +3V3 0 100n
L2 /+5VBK +5V 10u
C49 /NET0026 /+5VBK 100n
C67 0 /NET0024 33n
R31 0 /NET0093 21k
R13 /NET0046 /0ISOpH 10k
R46 /NET0046 /NET0056 16.9k
C86 /NET0056 /0ISOpH 10n
C28 /0ISOpH /NET0025 100n
C50 +3V3 0 100n
C22 +3V3 0 10n
C38 0 +3V3 100n
C3 0 +3V3 10u
C57 0 NA 2.2u
R38 0 /VREFNA 10.7k
R42 /VREFNA NA 14k
C81 0 +24V 100n
C87 0 +24V 100n
C16 /NET0055 +24V 100n
C45 /NET0086 /NET0083 22n
C5 0 +3V3 100n
R16 /NET0065 0 110m
R39 /NET0049 0 110m
R54 /VREFNB NB 14k
C62 0 NB 2.2u
R14 0 /VREFNB 10.7k
R34 /NET0054 0 110m
R22 /NET0053 0 110m

V_24V +24V 0 DC 24.0
V_3V3 +3V3 0 DC 3.3
V_5V +5V 0 DC 5.0

.control
tran 100u 10m
set filetype=ascii
write OPNhydro_r2_raw.raw all
.endc

.end
