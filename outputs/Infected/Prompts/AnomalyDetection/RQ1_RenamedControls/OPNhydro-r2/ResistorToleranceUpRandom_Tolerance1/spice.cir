.title KiCad schematic

C27 0 +24V 100n
C17 0 +3V3 10u
C22 0 +3V3 100n
C73 NET0013 +3V3 100n
R5 NET0055 +3V3 10k
R18 0 NET0013 10k
C11 0 NET0055 100n
C20 +5V 0 100u
R15 NET0083 /NET0043 100
R28 0 /NET0043 10k
C69 0 +24V 100n
C87 +24V 0 47u
R38 NET0055 /NET0060 4.7k
R32 NET0013 /NET0080 4.7k
R9 NET0011 /NET0082 100
C80 +24V 0 220u
R53 /NET0082 +3V3 10k
C60 0 +3V3 100n
C37 /NET0021 /NET0084 22n
C84 0 pH 2.2u
C6 0 +3V3 100n
C45 +24V 0 220u
R49 0 /VREFpH 10.7k
R52 /VREFpH pH 14k
C15 /NET0044 +24V 100n
C39 /NET0098 /NET0024 22n
C65 0 +24V 100n
C32 0 +24V 100n
R20 /NET0048 0 110m
R51 /NET0030 0 110m
C8 0 +24V 100n
C93 /NET0090 +24V 100n
C29 0 +24V 100n
C58 +24V 0 220u
C90 +24V 0 220u
C47 +24V 0 1000u
R22 /NET0010 /+24VF 33k
C81 0 +24V 10u
C50 0 +24V 100n
R42 NET0079 +3V3 2.2k
R56 NET0062 +3V3 2.2k
R30 Net-_M5A-TX1/IO22_ NET0015 1k
C9 /NET0031 /0ISOEC 10n
C40 /NET0031 /0ISOEC 100n
R7 /NET0087 /NET0031 2.2k
R45 /NET0036 /NET0031 2.2k
R48 /NET0005 /NET0031 16.9k
C12 0 +3V3 100n
C44 0 +3V3 10u
C21 /0ISOEC /NET0020 100n
C76 /0ISOEC /NET0020 10u
C62 0 +5V 10u
R54 8BK +5V 52.3k
R39 0 8BK 10k
C61 +5V 0 220u
C53 0 +5V 10u
C10 0 +5V 10u
C5 0 +3V3 22u
C51 /NET0097 /0ISOpH 100n
C52 /0ISOpH /NET0050 10u
R55 /NET0096 /NET0097 2.2k
R25 /NET0091 /NET0097 2.2k
C24 0 +3V3 100n
C19 0 +3V3 10u
R34 /NET0005 /0ISOEC 10k
C28 0 +3V3 10u
C54 +3V3 0 10n
C88 0 +3V3 100n
C34 +3V3 0 100n
L2 /+5VBK +5V 10u
C71 /NET0056 /+5VBK 100n
C31 0 /NET0004 33n
R44 0 /NET0076 21k
R27 /NET0009 /0ISOpH 10k
R12 /NET0009 /NET0097 16.9k
C96 /NET0097 /0ISOpH 10n
C95 /0ISOpH /NET0050 100n
C41 +3V3 0 100n
C66 +3V3 0 10n
C77 0 +3V3 100n
C72 0 +3V3 10u
C94 0 NA 2.2u
R1 0 /VREFNA 10.7k
R41 /VREFNA NA 14k
C33 0 +24V 100n
C4 0 +24V 100n
C13 /NET0042 +24V 100n
C7 /NET0078 /NET0014 22n
C38 0 +3V3 100n
R17 /NET0051 0 110m
R2 /NET0077 0 110m
R11 /VREFNB NB 14k
C18 0 NB 2.2u
R36 0 /VREFNB 10.7k
R46 /NET0018 0 110m
R35 /NET0049 0 110m

V_24V +24V 0 DC 24.0
V_3V3 +3V3 0 DC 3.3
V_5V +5V 0 DC 5.0

.control
tran 100u 10m
set filetype=ascii
write OPNhydro_r2_raw.raw all
.endc

.end
