.title KiCad schematic

C85 0 +24V 100n
C59 0 +3V3 10u
C39 0 +3V3 100n
C48 NET0084 +3V3 100n
R17 NET0052 +3V3 10k
R27 0 NET0084 10k
C7 0 NET0052 100n
C53 +5V 0 100u
R38 NET0027 /NET0021 100
R19 0 /NET0021 10k
C87 0 +24V 100n
C90 +24V 0 47u
R56 NET0052 /NET0033 4.7k
R50 NET0084 /NET0007 4.7k
R21 NET0049 /NET0085 100
C16 +24V 0 220u
R25 /NET0085 +3V3 10k
C84 0 +3V3 100n
C51 /NET0090 /NET0004 22n
C70 0 pH 2.2u
C34 0 +3V3 100n
C72 +24V 0 220u
R18 0 /VREFpH 10.7k
R40 /VREFpH pH 14k
C1 /NET0076 +24V 100n
C50 /NET0018 /NET0059 22n
C29 0 +24V 100n
C56 0 +24V 100n
R39 /NET0087 0 110m
R2 /NET0081 0 110m
C96 0 +24V 100n
C60 /NET0035 +24V 100n
C8 0 +24V 100n
C44 +24V 0 220u
C31 +24V 0 220u
C71 +24V 0 1000u
R15 /NET0047 /+24VF 33k
C83 0 +24V 10u
C73 0 +24V 100n
R29 NET0055 +3V3 2.2k
R49 NET0025 +3V3 2.2k
R52 Net-_M4A-TX1/IO22_ NET0023 1k
C26 /NET0073 /0ISOEC 10n
C65 /NET0073 /0ISOEC 100n
R44 /NET0020 /NET0073 2.2k
R5 /NET0083 /NET0073 2.2k
R20 /NET0009 /NET0073 16.9k
C36 0 +3V3 100n
C25 0 +3V3 10u
C95 /0ISOEC /NET0067 100n
C3 /0ISOEC /NET0067 10u
C52 0 +5V 10u
R47 8BK +5V 52.3k
R14 0 8BK 10k
C64 +5V 0 220u
C67 0 +5V 10u
C80 0 +5V 10u
C75 0 +3V3 22u
C74 /NET0058 /0ISOpH 100n
C55 /0ISOpH /NET0079 10u
R48 /NET0013 /NET0058 2.2k
R33 /NET0095 /NET0058 2.2k
C32 0 +3V3 100n
C88 0 +3V3 10u
R30 /NET0009 /0ISOEC 10k
C54 0 +3V3 10u
C93 +3V3 0 10n
C43 0 +3V3 100n
C22 +3V3 0 100n
L2 /+5VBK +5V 10u
C30 /NET0010 /+5VBK 100n
C47 0 /NET0043 33n
R36 0 /NET0099 21k
R4 /NET0050 /0ISOpH 10k
R37 /NET0050 /NET0058 16.9k
C4 /NET0058 /0ISOpH 10n
C20 /0ISOpH /NET0079 100n
C69 +3V3 0 100n
C10 +3V3 0 10n
C63 0 +3V3 100n
C19 0 +3V3 10u
C21 0 NA 2.2u
R1 0 /VREFNA 10.7k
R45 /VREFNA NA 14k
C27 0 +24V 100n
C15 0 +24V 100n
C9 /NET0034 +24V 100n
C76 /NET0039 /NET0065 22n
C2 0 +3V3 100n
R34 /NET0045 0 110m
R10 /NET0062 0 110m
R31 /VREFNB NB 14k
C35 0 NB 2.2u
R41 0 /VREFNB 10.7k
R11 /NET0012 0 110m
R26 /NET0024 0 110m

V_24V +24V 0 DC 24.0
V_3V3 +3V3 0 DC 3.3
V_5V +5V 0 DC 5.0

.control
tran 100u 10m
set filetype=ascii
write OPNhydro_r2_raw.raw all
.endc

.end
