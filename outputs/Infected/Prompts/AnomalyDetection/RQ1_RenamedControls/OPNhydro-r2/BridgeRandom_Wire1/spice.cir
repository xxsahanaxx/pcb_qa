.title KiCad schematic

C4 0 +24V 100n
C29 0 +3V3 10u
C52 0 +3V3 100n
C56 NET0079 +3V3 100n
R5 NET0062 +3V3 10k
R17 0 NET0079 10k
C49 0 NET0062 100n
C79 +5V 0 100u
R30 NET0035 /NET0060 100
R47 0 /NET0060 10k
C76 0 +24V 100n
C90 +24V 0 47u
R12 NET0062 /NET0006 4.7k
R48 NET0079 /NET0015 4.7k
R9 NET0092 /NET0055 100
C78 +24V 0 220u
R16 /NET0055 +3V3 10k
C12 0 +3V3 100n
C35 /NET0084 /NET0024 22n
C41 0 pH 2.2u
C54 0 +3V3 100n
C91 +24V 0 220u
R55 0 /VREFpH 10.7k
R8 /VREFpH pH 14k
C86 /NET0002 +24V 100n
C17 /NET0081 /NET0047 22n
C44 0 +24V 100n
C51 0 +24V 100n
R13 /NET0010 0 110m
R56 /NET0071 0 110m
C58 0 +24V 100n
C31 /NET0078 +24V 100n
C66 0 +24V 100n
C71 +24V 0 220u
C24 +24V 0 220u
C30 +24V 0 1000u
R35 /NET0074 /+24VF 33k
C70 0 +24V 10u
C63 0 +24V 100n
R26 NET0049 +3V3 2.2k
R37 NET0031 +3V3 2.2k
R45 Net-_M5A-TX1/IO22_ NET0048 1k
C53 /NET0089 /0ISOEC 10n
C32 /NET0089 /0ISOEC 100n
R42 /NET0032 /NET0089 2.2k
R22 /NET0096 /NET0089 2.2k
R4 /NET0027 /NET0089 16.9k
C18 0 +3V3 100n
C33 0 +3V3 10u
C87 /0ISOEC /NET0095 100n
C64 /0ISOEC /NET0095 10u
C10 0 +5V 10u
R43 8BK +5V 52.3k
R25 0 8BK 10k
C85 +5V 0 220u
C14 0 +5V 10u
C7 0 +5V 10u
C81 0 +3V3 22u
C92 /NET0020 /0ISOpH 100n
C57 /0ISOpH /NET0009 10u
R49 /NET0025 /NET0020 2.2k
R44 /NET0007 /NET0020 2.2k
C60 0 +3V3 100n
C69 0 +3V3 10u
R33 /NET0027 /0ISOEC 10k
C73 0 +3V3 10u
C39 +3V3 0 10n
C28 0 +3V3 100n
C40 +3V3 0 100n
L2 /+5VBK +5V 10u
C25 /NET0039 /+5VBK 100n
C13 0 /NET0076 33n
R41 0 /NET0061 21k
R51 /NET0059 /0ISOpH 10k
R6 /NET0059 /NET0020 16.9k
C55 /NET0020 /0ISOpH 10n
C23 /0ISOpH /NET0009 100n
C11 +3V3 0 100n
C95 +3V3 0 10n
C94 0 +3V3 100n
C82 0 +3V3 10u
C26 0 NA 2.2u
R40 0 /VREFNA 10.7k
R2 /VREFNA NA 14k
C37 0 +24V 100n
C96 0 +24V 100n
C48 /NET0034 +24V 100n
C5 /NET0019 /NET0099 22n
C80 0 +3V3 100n
R53 /NET0008 0 110m
R14 /NET0033 0 110m
R3 /VREFNB NB 14k
C59 0 NB 2.2u
R7 0 /VREFNB 10.7k
R52 /NET0030 0 110m
R54 /NET0067 0 110m

V_24V +24V 0 DC 24.0
V_3V3 +3V3 0 DC 3.3
V_5V +5V 0 DC 5.0

.control
tran 100u 10m
set filetype=ascii
write OPNhydro_r2_raw.raw all
.endc

.end
