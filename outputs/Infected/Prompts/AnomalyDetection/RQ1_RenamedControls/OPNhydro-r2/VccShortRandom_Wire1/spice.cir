.title KiCad schematic

C6 0 +24V 100n
C10 0 +3V3 10u
C50 0 +3V3 100n
C56 NET0015 +3V3 100n
R46 NET0068 +3V3 10k
R53 0 NET0015 10k
C57 0 NET0068 100n
C48 +5V 0 100u
R41 NET0095 /NET0046 100
R21 0 /NET0046 10k
C74 0 +24V 100n
C3 +24V 0 47u
R54 NET0068 /NET0077 4.7k
R37 NET0015 /NET0039 4.7k
R32 NET0078 /NET0031 100
C73 +24V 0 220u
R34 /NET0031 +3V3 10k
C45 0 +3V3 100n
C69 /NET0066 /NET0022 22n
C88 0 pH 2.2u
C78 0 +3V3 100n
C26 +24V 0 220u
R17 0 /VREFpH 10.7k
R9 /VREFpH pH 14k
C92 /NET0096 +24V 100n
C38 /NET0018 /NET0062 22n
C1 0 +24V 100n
C81 0 +24V 100n
R5 /NET0007 0 110m
R39 /NET0032 0 110m
C2 0 +24V 100n
C58 /NET0064 +24V 100n
C93 0 +24V 100n
C79 +24V 0 220u
C47 +24V 0 220u
C71 +24V 0 1000u
R51 /NET0090 /+24VF 33k
C54 0 +24V 10u
C52 0 +24V 100n
R31 NET0034 +3V3 2.2k
R20 NET0087 +3V3 2.2k
R1 Net-_M3A-TX1/IO22_ NET0017 1k
C30 /NET0063 /0ISOEC 10n
C91 /NET0063 /0ISOEC 100n
R23 /NET0060 /NET0063 2.2k
R14 /NET0091 /NET0063 2.2k
R3 /NET0072 /NET0063 16.9k
C36 0 +3V3 100n
C83 0 +3V3 10u
C90 /0ISOEC /NET0010 100n
C16 /0ISOEC /NET0010 10u
C31 0 +5V 10u
R6 8BK +5V 52.3k
R28 0 8BK 10k
C55 +5V 0 220u
C11 0 +5V 10u
C44 0 +5V 10u
C37 0 +3V3 22u
C28 /NET0019 /0ISOpH 100n
C13 /0ISOpH /NET0023 10u
R35 /NET0076 /NET0019 2.2k
R26 /NET0099 /NET0019 2.2k
C8 0 +3V3 100n
C20 0 +3V3 10u
R8 /NET0072 /0ISOEC 10k
C12 0 +3V3 10u
C22 +3V3 0 10n
C32 0 +3V3 100n
C34 +3V3 0 100n
L2 /+5VBK +5V 10u
C94 /NET0041 /+5VBK 100n
C64 0 /NET0075 33n
R18 0 /NET0059 21k
R44 /NET0069 /0ISOpH 10k
R49 /NET0069 /NET0019 16.9k
C7 /NET0019 /0ISOpH 10n
C62 /0ISOpH /NET0023 100n
C86 +3V3 0 100n
C9 +3V3 0 10n
C66 0 +3V3 100n
C46 0 +3V3 10u
C51 0 NA 2.2u
R19 0 /VREFNA 10.7k
R55 /VREFNA NA 14k
C84 0 +24V 100n
C59 0 +24V 100n
C61 /NET0093 +24V 100n
C70 /NET0036 /NET0025 22n
C43 0 +3V3 100n
R29 /NET0073 0 110m
R13 /NET0080 0 110m
R22 /VREFNB NB 14k
C87 0 NB 2.2u
R4 0 /VREFNB 10.7k
R38 /NET0071 0 110m
R43 /NET0082 0 110m

V_24V +24V 0 DC 24.0
V_3V3 +3V3 0 DC 3.3
V_5V +5V 0 DC 5.0

.control
tran 100u 10m
set filetype=ascii
write OPNhydro_r2_raw.raw all
.endc

.end
