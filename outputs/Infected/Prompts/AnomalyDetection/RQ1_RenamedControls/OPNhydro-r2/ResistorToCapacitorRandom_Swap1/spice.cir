.title KiCad schematic

C30 0 +24V 100n
C57 0 +3V3 10u
C10 0 +3V3 100n
C35 NET0081 +3V3 100n
R29 NET0029 +3V3 10k
R56 0 NET0081 10k
C49 0 NET0029 100n
C20 +5V 0 100u
R23 NET0078 /NET0063 100
R31 0 /NET0063 10k
C83 0 +24V 100n
C53 +24V 0 47u
R22 NET0029 /NET0003 4.7k
R51 NET0081 /NET0082 4.7k
R18 NET0004 /NET0062 100
C71 +24V 0 220u
R21 /NET0062 +3V3 10k
C26 0 +3V3 100n
C15 /NET0075 /NET0006 22n
C42 0 pH 2.2u
C45 0 +3V3 100n
C41 +24V 0 220u
R42 0 /VREFpH 10.7k
R39 /VREFpH pH 14k
C21 /NET0044 +24V 100n
C1 /NET0069 /NET0039 22n
C50 0 +24V 100n
C25 0 +24V 100n
R38 /NET0023 0 110m
R45 /NET0035 0 110m
C93 0 +24V 100n
C54 /NET0095 +24V 100n
C58 0 +24V 100n
C96 +24V 0 220u
C68 +24V 0 220u
C66 +24V 0 1000u
R24 /NET0060 /+24VF 33k
C3 0 +24V 10u
C4 0 +24V 100n
R48 NET0037 +3V3 2.2k
R53 NET0092 +3V3 2.2k
R2 Net-_M5A-TX1/IO22_ NET0047 1k
C24 /NET0048 /0ISOEC 10n
C67 /NET0048 /0ISOEC 100n
R30 /NET0072 /NET0048 2.2k
R50 /NET0028 /NET0048 2.2k
R55 /NET0014 /NET0048 16.9k
C59 0 +3V3 100n
C46 0 +3V3 10u
C76 /0ISOEC /NET0071 100n
C84 /0ISOEC /NET0071 10u
C63 0 +5V 10u
R40 8BK +5V 52.3k
R16 0 8BK 10k
C12 +5V 0 220u
C36 0 +5V 10u
C65 0 +5V 10u
C40 0 +3V3 22u
C38 /NET0013 /0ISOpH 100n
C92 /0ISOpH /NET0088 10u
R46 /NET0027 /NET0013 2.2k
R41 /NET0074 /NET0013 2.2k
C23 0 +3V3 100n
C52 0 +3V3 10u
R33 /NET0014 /0ISOEC 10k
C95 0 +3V3 10u
C56 +3V3 0 10n
C62 0 +3V3 100n
C75 +3V3 0 100n
L2 /+5VBK +5V 10u
C39 /NET0012 /+5VBK 100n
C78 0 /NET0022 33n
R15 0 /NET0087 21k
R9 /NET0045 /0ISOpH 10k
R13 /NET0045 /NET0013 16.9k
C86 /NET0013 /0ISOpH 10n
C2 /0ISOpH /NET0088 100n
C74 +3V3 0 100n
C81 +3V3 0 10n
C47 0 +3V3 100n
C90 0 +3V3 10u
C13 0 NA 2.2u
R26 0 /VREFNA 10.7k
R1 /VREFNA NA 14k
C72 0 +24V 100n
C85 0 +24V 100n
C91 /NET0098 +24V 100n
C31 /NET0053 /NET0070 22n
C55 0 +3V3 100n
R35 /NET0032 0 110m
R14 /NET0083 0 110m
R4 /VREFNB NB 14k
C28 0 NB 2.2u
R34 0 /VREFNB 10.7k
R27 /NET0094 0 110m
R36 /NET0040 0 110m

V_24V +24V 0 DC 24.0
V_3V3 +3V3 0 DC 3.3
V_5V +5V 0 DC 5.0

.control
tran 100u 10m
set filetype=ascii
write OPNhydro_r2_raw.raw all
.endc

.end
