.title KiCad schematic

C22 0 +24V 100n
C24 0 +3V3 10u
C42 0 +3V3 100n
C29 NET0051 +3V3 100n
R30 NET0032 +3V3 10k
R25 0 NET0051 10k
C2 0 NET0032 100n
C19 +5V 0 100u
R54 NET0065 /NET0076 100
R11 0 /NET0076 10k
C14 0 +24V 100n
C15 +24V 0 47u
R7 NET0032 /NET0091 4.7k
R50 NET0051 /NET0081 4.7k
R26 NET0010 /NET0055 100
C45 +24V 0 220u
R20 /NET0055 +3V3 10k
C69 0 +3V3 100n
C77 /NET0035 /NET0044 22n
C92 0 pH 2.2u
C83 0 +3V3 100n
C63 +24V 0 220u
R16 0 /VREFpH 10.7k
R41 /VREFpH pH 14k
C43 /NET0040 +24V 100n
C94 /NET0097 /NET0026 22n
C7 0 +24V 100n
C28 0 +24V 100n
R38 /NET0075 0 110m
R48 /NET0027 0 110m
C86 0 +24V 100n
C84 /NET0096 +24V 100n
C21 0 +24V 100n
C12 +24V 0 220u
C78 +24V 0 220u
C4 +24V 0 1000u
R39 /NET0015 /+24VF 33k
C55 0 +24V 10u
C71 0 +24V 100n
R1 NET0025 +3V3 2.2k
R13 NET0062 +3V3 2.2k
R40 Net-_M4A-TX1/IO22_ NET0034 1k
C32 /NET0013 /0ISOEC 10n
C25 /NET0013 /0ISOEC 100n
R5 /NET0005 /NET0013 2.2k
R37 /NET0038 /NET0013 2.2k
R36 /NET0098 /NET0013 16.9k
C48 0 +3V3 100n
C67 0 +3V3 10u
C91 /0ISOEC /NET0069 100n
C30 /0ISOEC /NET0069 10u
C58 0 +5V 10u
R46 8BK +5V 52.3k
R55 0 8BK 10k
C57 +5V 0 220u
C26 0 +5V 10u
C85 0 +5V 10u
C90 0 +3V3 22u
C74 /NET0080 /0ISOpH 100n
C9 /0ISOpH /NET0056 10u
R44 /NET0086 /NET0080 2.2k
R42 /NET0024 /NET0080 2.2k
C89 0 +3V3 100n
C18 0 +3V3 10u
R53 /NET0098 /0ISOEC 10k
C95 0 +3V3 10u
C87 +3V3 0 10n
C76 0 +3V3 100n
C31 +3V3 0 100n
L2 /+5VBK +5V 10u
C52 /NET0011 /+5VBK 100n
C62 0 /NET0033 33n
R35 0 /NET0008 21k
R43 /NET0093 /0ISOpH 10k
R52 /NET0093 /NET0080 16.9k
C50 /NET0080 /0ISOpH 10n
C37 /0ISOpH /NET0056 100n
C33 +3V3 0 100n
C72 +3V3 0 10n
C68 0 +3V3 100n
C20 0 +3V3 10u
C35 0 NA 2.2u
R21 0 /VREFNA 10.7k
R19 /VREFNA NA 14k
C16 0 +24V 100n
C51 0 +24V 100n
C82 /NET0099 +24V 100n
C6 /NET0087 /NET0030 22n
C59 0 +3V3 100n
R15 /NET0046 0 110m
R51 /NET0002 0 110m
R3 /VREFNB NB 14k
C3 0 NB 2.2u
R17 0 /VREFNB 10.7k
R31 /NET0073 0 110m
R27 /NET0083 0 110m

V_24V +24V 0 DC 24.0
V_3V3 +3V3 0 DC 3.3
V_5V +5V 0 DC 5.0

.control
tran 100u 10m
set filetype=ascii
write OPNhydro_r2_raw.raw all
.endc

.end
