.title KiCad schematic

C81 0 +24V 100n
C54 0 +3V3 10u
C4 0 +3V3 100n
C65 NET0036 +3V3 100n
R40 NET0042 +3V3 10k
R21 0 NET0036 10k
C76 0 NET0042 100n
C93 +5V 0 100u
R4 NET0043 /NET0009 100
R26 0 /NET0009 10k
C73 0 +24V 100n
C20 +24V 0 47u
R39 NET0042 /NET0008 4.7k
R55 NET0036 /NET0024 4.7k
R18 NET0085 /NET0004 100
C48 +24V 0 220u
R3 /NET0004 +3V3 10k
C85 0 +3V3 100n
C70 /NET0045 /NET0099 22n
C19 0 pH 2.2u
C49 0 +3V3 100n
C75 +24V 0 220u
R35 0 /VREFpH 10.7k
R2 /VREFpH pH 14k
C55 /NET0052 +24V 100n
C21 /NET0063 /NET0016 22n
C8 0 +24V 100n
C50 0 +24V 100n
R54 /NET0051 0 110m
R8 /NET0029 0 110m
C31 0 +24V 100n
C17 /NET0015 +24V 100n
C79 0 +24V 100n
C16 +24V 0 220u
C43 +24V 0 220u
C11 +24V 0 1000u
R12 /NET0034 /+24VF 33k
C37 0 +24V 10u
C84 0 +24V 100n
R43 NET0046 +3V3 2.2k
R49 NET0031 +3V3 2.2k
R34 Net-_M3A-TX1/IO22_ NET0003 1k
C74 /NET0071 /0ISOEC 10n
C69 /NET0071 /0ISOEC 100n
R6 /NET0088 /NET0071 2.2k
R46 /NET0012 /NET0071 2.2k
R33 /NET0028 /NET0071 16.9k
C59 0 +3V3 100n
C53 0 +3V3 10u
C39 /0ISOEC /NET0078 100n
C34 /0ISOEC /NET0078 10u
C60 0 +5V 10u
R53 8BK +5V 52.3k
R36 0 8BK 10k
C44 +5V 0 220u
C45 0 +5V 10u
C66 0 +5V 10u
C22 0 +3V3 22u
C89 /NET0044 /0ISOpH 100n
C27 /0ISOpH /NET0098 10u
R19 /NET0084 /NET0044 2.2k
R42 /NET0033 /NET0044 2.2k
C13 0 +3V3 100n
C63 0 +3V3 10u
R37 /NET0028 /0ISOEC 10k
C28 0 +3V3 10u
C77 +3V3 0 10n
C5 0 +3V3 100n
C61 +3V3 0 100n
L2 /+5VBK +5V 10u
C36 /NET0006 /+5VBK 100n
C1 0 /NET0094 33n
R10 0 /NET0053 21k
R56 /NET0035 /0ISOpH 10k
R17 /NET0035 /NET0044 16.9k
C6 /NET0044 /0ISOpH 10n
C18 /0ISOpH /NET0098 100n
C41 +3V3 0 100n
C78 +3V3 0 10n
C26 0 +3V3 100n
C7 0 +3V3 10u
C62 0 NA 2.2u
R31 0 /VREFNA 10.7k
R25 /VREFNA NA 14k
C87 0 +24V 100n
C40 0 +24V 100n
C23 /NET0058 +24V 100n
C42 /NET0032 /NET0089 22n
C95 0 +3V3 100n
R51 /NET0055 0 110m
R27 /NET0011 0 110m
R20 /VREFNB NB 14k
C58 0 NB 2.2u
R32 0 /VREFNB 10.7k
R52 /NET0066 0 110m
R48 /NET0067 0 110m

V_24V +24V 0 DC 24.0
V_3V3 +3V3 0 DC 3.3
V_5V +5V 0 DC 5.0

.control
tran 100u 10m
set filetype=ascii
write OPNhydro_r2_raw.raw all
.endc

.end
