.title KiCad schematic

C73 0 +24V 100n
C24 0 +3V3 10u
C78 0 +3V3 100n
C62 NET0042 +3V3 100n
R55 NET0024 +3V3 10k
R40 0 NET0042 10k
C3 0 NET0024 100n
C87 +5V 0 100u
R49 NET0078 /NET0012 100
R52 0 /NET0012 10k
C23 0 +24V 100n
C10 +24V 0 47u
R14 NET0024 /NET0052 4.7k
R17 NET0042 /NET0057 4.7k
R21 NET0037 /NET0023 100
C83 +24V 0 220u
R12 /NET0023 +3V3 10k
C27 0 +3V3 100n
C32 /NET0075 /NET0036 22n
C9 0 pH 2.2u
C15 0 +3V3 100n
C7 +24V 0 220u
R33 0 /VREFpH 10.7k
R23 /VREFpH pH 14k
C14 /NET0004 +24V 100n
C84 /NET0027 /NET0015 22n
C12 0 +24V 100n
C68 0 +24V 100n
R2 /NET0074 0 110m
R5 /NET0018 0 110m
C6 0 +24V 100n
C51 /NET0097 +24V 100n
C54 0 +24V 100n
C75 +24V 0 220u
C31 +24V 0 220u
C67 +24V 0 1000u
R10 /NET0067 /+24VF 33k
C1 0 +24V 10u
C44 0 +24V 100n
R34 NET0049 +3V3 2.2k
R38 NET0053 +3V3 2.2k
R20 Net-_M2A-TX1/IO22_ NET0035 1k
C82 /NET0060 /0ISOEC 10n
C92 /NET0060 /0ISOEC 100n
R56 /NET0090 /NET0060 2.2k
R29 /NET0030 /NET0060 2.2k
R11 /NET0048 /NET0060 16.9k
C22 0 +3V3 100n
C72 0 +3V3 10u
C18 /0ISOEC /NET0069 100n
C30 /0ISOEC /NET0069 10u
C39 0 +5V 10u
R31 8BK +5V 52.3k
R6 0 8BK 10k
C19 +5V 0 220u
C17 0 +5V 10u
C55 0 +5V 10u
C65 0 +3V3 22u
C89 /NET0071 /0ISOpH 100n
C43 /0ISOpH /NET0003 10u
R47 /NET0068 /NET0071 2.2k
R27 /NET0039 /NET0071 2.2k
C93 0 +3V3 100n
C77 0 +3V3 10u
R19 /NET0048 /0ISOEC 10k
C57 0 +3V3 10u
C38 +3V3 0 10n
C40 0 +3V3 100n
C91 +3V3 0 100n
L2 /+5VBK +5V 10u
C33 /NET0091 /+5VBK 100n
C46 0 /NET0099 33n
R48 0 /NET0013 21k
R28 /NET0080 /0ISOpH 10k
R39 /NET0080 /NET0071 16.9k
C48 /NET0071 /0ISOpH 10n
C85 /0ISOpH /NET0003 100n
C74 +3V3 0 100n
C26 +3V3 0 10n
C4 0 +3V3 100n
C47 0 +3V3 10u
C21 0 NA 2.2u
R3 0 /VREFNA 10.7k
R43 /VREFNA NA 14k
C53 0 +24V 100n
C25 0 +24V 100n
C2 /NET0051 +24V 100n
C41 /NET0029 /NET0019 22n
C64 0 +3V3 100n
R35 /NET0092 0 110m
R26 /NET0009 0 110m
R41 /VREFNB NB 14k
C36 0 NB 2.2u
R25 0 /VREFNB 10.7k
R1 /NET0017 0 110m
R51 /NET0002 0 110m

V_24V +24V 0 DC 24.0
V_3V3 +3V3 0 DC 3.3
V_5V +5V 0 DC 5.0

.control
tran 100u 10m
set filetype=ascii
write OPNhydro_r2_raw.raw all
.endc

.end
