.title KiCad schematic

C29 0 +24V 100n
C48 0 +3V3 10u
C6 0 +3V3 100n
C49 NET0056 +3V3 100n
R46 NET0024 +3V3 10k
R41 0 NET0056 10k
C85 0 NET0024 100n
C62 +5V 0 100u
R48 NET0071 /NET0061 100
R19 0 /NET0061 10k
C65 0 +24V 100n
C77 +24V 0 47u
R3 NET0024 /NET0073 4.7k
R13 NET0056 /NET0054 4.7k
R15 NET0009 /NET0044 100
C20 +24V 0 220u
R9 /NET0044 +3V3 10k
C82 0 +3V3 100n
C51 /NET0078 /NET0097 22n
C94 0 pH 2.2u
C41 0 +3V3 100n
C90 +24V 0 220u
R6 0 /VREFpH 10.7k
R36 /VREFpH pH 14k
C43 /NET0031 +24V 100n
C47 /NET0025 /NET0005 22n
C36 0 +24V 100n
C58 0 +24V 100n
R24 /NET0068 0 110m
R43 /NET0043 0 110m
C10 0 +24V 100n
C70 /NET0003 +24V 100n
C26 0 +24V 100n
C87 +24V 0 220u
C57 +24V 0 220u
C91 +24V 0 1000u
R32 /NET0094 /+24VF 33k
C11 0 +24V 10u
C74 0 +24V 100n
R40 NET0063 +3V3 2.2k
R2 NET0084 +3V3 2.2k
R29 Net-_M3A-TX1/IO22_ NET0046 1k
C16 /NET0042 /0ISOEC 10n
C71 /NET0042 /0ISOEC 100n
R45 /NET0035 /NET0042 2.2k
R22 /NET0038 /NET0042 2.2k
R14 /NET0091 /NET0042 16.9k
C35 0 +3V3 100n
C44 0 +3V3 10u
C30 /0ISOEC /NET0082 100n
C7 /0ISOEC /NET0082 10u
C39 0 +5V 10u
R53 8BK +5V 52.3k
R23 0 8BK 10k
C89 +5V 0 220u
C73 0 +5V 10u
C37 0 +5V 10u
C25 0 +3V3 22u
C64 /NET0080 /0ISOpH 100n
C54 /0ISOpH /NET0016 10u
R51 /NET0079 /NET0080 2.2k
R44 /NET0004 /NET0080 2.2k
C72 0 +3V3 100n
C13 0 +3V3 10u
R31 /NET0091 /0ISOEC 10k
C92 0 +3V3 10u
C80 +3V3 0 10n
C14 0 +3V3 100n
C45 +3V3 0 100n
L2 /+5VBK +5V 10u
C28 /NET0098 /+5VBK 100n
C23 0 /NET0089 33n
R47 0 /NET0057 21k
R54 /NET0040 /0ISOpH 10k
R8 /NET0040 /NET0080 16.9k
C86 /NET0080 /0ISOpH 10n
C66 /0ISOpH /NET0016 100n
C61 +3V3 0 100n
C9 +3V3 0 10n
C81 0 +3V3 100n
C21 0 +3V3 10u
C40 0 NA 2.2u
R20 0 /VREFNA 10.7k
R5 /VREFNA NA 14k
C68 0 +24V 100n
C33 0 +24V 100n
C22 /NET0030 +24V 100n
C93 /NET0072 /NET0047 22n
C76 0 +3V3 100n
R35 /NET0066 0 110m
R34 /NET0034 0 110m
R18 /VREFNB NB 14k
C5 0 NB 2.2u
R27 0 /VREFNB 10.7k
R1 /NET0002 0 110m
R26 /NET0065 0 110m

V_24V +24V 0 DC 24.0
V_3V3 +3V3 0 DC 3.3
V_5V +5V 0 DC 5.0

.control
tran 100u 10m
set filetype=ascii
write OPNhydro_r2_raw.raw all
.endc

.end
