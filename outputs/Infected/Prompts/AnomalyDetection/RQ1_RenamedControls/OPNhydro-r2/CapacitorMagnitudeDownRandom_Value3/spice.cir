.title KiCad schematic

C52 0 +24V 100n
C51 0 +3V3 10u
C59 0 +3V3 100n
C55 NET0031 +3V3 100n
R29 NET0014 +3V3 10k
R25 0 NET0031 10k
C8 0 NET0014 100n
C91 +5V 0 100u
R36 NET0051 /NET0001 100
R46 0 /NET0001 10k
C13 0 +24V 100n
C45 +24V 0 47u
R45 NET0014 /NET0053 4.7k
R20 NET0031 /NET0060 4.7k
R32 NET0077 /NET0042 100
C96 +24V 0 220u
R3 /NET0042 +3V3 10k
C76 0 +3V3 100n
C29 /NET0062 /NET0073 22n
C94 0 pH 2.2u
C57 0 +3V3 100n
C26 +24V 0 220u
R22 0 /VREFpH 10.7k
R12 /VREFpH pH 14k
C92 /NET0039 +24V 100n
C36 /NET0036 /NET0058 22n
C20 0 +24V 100n
C18 0 +24V 100n
R31 /NET0079 0 110m
R41 /NET0048 0 110m
C27 0 +24V 100n
C25 /NET0064 +24V 100n
C4 0 +24V 100n
C48 +24V 0 220u
C3 +24V 0 220u
C30 +24V 0 1000u
R40 /NET0022 /+24VF 33k
C12 0 +24V 10u
C73 0 +24V 100n
R52 NET0030 +3V3 2.2k
R44 NET0081 +3V3 2.2k
R37 Net-_M5A-TX1/IO22_ NET0086 1k
C44 /NET0007 /0ISOEC 10n
C38 /NET0007 /0ISOEC 100n
R9 /NET0092 /NET0007 2.2k
R56 /NET0033 /NET0007 2.2k
R34 /NET0098 /NET0007 16.9k
C68 0 +3V3 100n
C77 0 +3V3 10u
C6 /0ISOEC /NET0035 100n
C43 /0ISOEC /NET0035 10u
C32 0 +5V 10u
R11 8BK +5V 52.3k
R54 0 8BK 10k
C5 +5V 0 220u
C47 0 +5V 10u
C78 0 +5V 10u
C80 0 +3V3 22u
C50 /NET0076 /0ISOpH 100n
C56 /0ISOpH /NET0078 10u
R38 /NET0041 /NET0076 2.2k
R18 /NET0095 /NET0076 2.2k
C64 0 +3V3 100n
C63 0 +3V3 10u
R27 /NET0098 /0ISOEC 10k
C85 0 +3V3 10u
C62 +3V3 0 10n
C46 0 +3V3 100n
C31 +3V3 0 100n
L2 /+5VBK +5V 10u
C17 /NET0004 /+5VBK 100n
C21 0 /NET0043 33n
R28 0 /NET0061 21k
R1 /NET0045 /0ISOpH 10k
R24 /NET0045 /NET0076 16.9k
C11 /NET0076 /0ISOpH 10n
C19 /0ISOpH /NET0078 100n
C40 +3V3 0 100n
C89 +3V3 0 10n
C37 0 +3V3 100n
C33 0 +3V3 10u
C58 0 NA 2.2u
R50 0 /VREFNA 10.7k
R6 /VREFNA NA 14k
C41 0 +24V 100n
C1 0 +24V 100n
C67 /NET0065 +24V 100n
C16 /NET0020 /NET0087 22n
C87 0 +3V3 100n
R17 /NET0080 0 110m
R19 /NET0006 0 110m
R21 /VREFNB NB 14k
C14 0 NB 2.2u
R5 0 /VREFNB 10.7k
R7 /NET0009 0 110m
R39 /NET0003 0 110m

V_24V +24V 0 DC 24.0
V_3V3 +3V3 0 DC 3.3
V_5V +5V 0 DC 5.0

.control
tran 100u 10m
set filetype=ascii
write OPNhydro_r2_raw.raw all
.endc

.end
