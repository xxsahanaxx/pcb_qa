.title KiCad schematic

C6 0 +24V 100n
C7 0 +3V3 10u
C21 0 +3V3 100n
C78 NET0080 +3V3 100n
R27 NET0018 +3V3 10k
R53 0 NET0080 10k
C65 0 NET0018 100n
C33 +5V 0 100u
R6 NET0041 /NET0035 100
R9 0 /NET0035 10k
C72 0 +24V 100n
C89 +24V 0 47u
R52 NET0018 /NET0092 4.7k
R15 NET0080 /NET0015 4.7k
R40 NET0028 /NET0023 100
C25 +24V 0 220u
R21 /NET0023 +3V3 10k
C30 0 +3V3 100n
C71 /NET0013 /NET0016 22n
C44 0 pH 2.2u
C50 0 +3V3 100n
C20 +24V 0 220u
R1 0 /VREFpH 10.7k
R5 /VREFpH pH 14k
C24 /NET0099 +24V 100n
C31 /NET0086 /NET0085 22n
C15 0 +24V 100n
C45 0 +24V 100n
R17 /NET0053 0 110m
R33 /NET0004 0 110m
C13 0 +24V 100n
C36 /NET0052 +24V 100n
C66 0 +24V 100n
C68 +24V 0 220u
C87 +24V 0 220u
C84 +24V 0 1000u
R32 /NET0019 /+24VF 33k
C5 0 +24V 10u
C1 0 +24V 100n
R36 NET0008 +3V3 2.2k
R26 NET0032 +3V3 2.2k
R31 Net-_M3A-TX1/IO22_ NET0082 1k
C14 /NET0070 /0ISOEC 10n
C59 /NET0070 /0ISOEC 100n
R11 /NET0054 /NET0070 2.2k
R30 /NET0081 /NET0070 2.2k
R43 /NET0006 /NET0070 16.9k
C86 0 +3V3 100n
C76 0 +3V3 10u
C51 /0ISOEC /NET0069 100n
C62 /0ISOEC /NET0069 10u
C57 0 +5V 10u
R45 8BK +5V 52.3k
R2 0 8BK 10k
C77 +5V 0 220u
C46 0 +5V 10u
C58 0 +5V 10u
C93 0 +3V3 22u
C32 /NET0084 /0ISOpH 100n
C48 /0ISOpH /NET0034 10u
R28 /NET0042 /NET0084 2.2k
R50 /NET0095 /NET0084 2.2k
C39 0 +3V3 100n
C88 0 +3V3 10u
R48 /NET0006 /0ISOEC 10k
C55 0 +3V3 10u
C85 +3V3 0 10n
C11 0 +3V3 100n
C19 +3V3 0 100n
L2 /+5VBK +5V 10u
C69 /NET0043 /+5VBK 100n
C79 0 /NET0094 33n
R16 0 /NET0062 21k
R42 /NET0098 /0ISOpH 10k
R38 /NET0098 /NET0084 16.9k
C8 /NET0084 /0ISOpH 10n
C2 /0ISOpH /NET0034 100n
C40 +3V3 0 100n
C75 +3V3 0 10n
C54 0 +3V3 100n
C12 0 +3V3 10u
C95 0 NA 2.2u
R49 0 /VREFNA 10.7k
R55 /VREFNA NA 14k
C83 0 +24V 100n
C67 0 +24V 100n
C49 /NET0076 +24V 100n
C92 /NET0029 /NET0063 22n
C61 0 +3V3 100n
R20 /NET0051 0 110m
R23 /NET0077 0 110m
R35 /VREFNB NB 14k
C47 0 NB 2.2u
R10 0 /VREFNB 10.7k
R22 /NET0056 0 110m
R8 /NET0012 0 110m

V_24V +24V 0 DC 24.0
V_3V3 +3V3 0 DC 3.3
V_5V +5V 0 DC 5.0

.control
tran 100u 10m
set filetype=ascii
write OPNhydro_r2_raw.raw all
.endc

.end
