.title KiCad schematic

C67 0 +24V 100n
C94 0 +3V3 10u
C81 0 +3V3 100n
C28 NET0034 +3V3 100n
R21 NET0076 +3V3 10k
R13 0 NET0034 10k
C26 0 NET0076 100n
C53 +5V 0 100u
R12 NET0026 /NET0041 100
R43 0 /NET0041 10k
C10 0 +24V 100n
C85 +24V 0 47u
R49 NET0076 /NET0090 4.7k
R52 NET0034 /NET0097 4.7k
R4 NET0021 /NET0056 100
C91 +24V 0 220u
R29 /NET0056 +3V3 10k
C5 0 +3V3 100n
C78 /NET0020 /NET0017 22n
C22 0 pH 2.2u
C30 0 +3V3 100n
C46 +24V 0 220u
R18 0 /VREFpH 10.7k
R26 /VREFpH pH 14k
C83 /NET0067 +24V 100n
C72 /NET0065 /NET0072 22n
C3 0 +24V 100n
C23 0 +24V 100n
R10 /NET0011 0 110m
R30 /NET0096 0 110m
C88 0 +24V 100n
C45 /NET0083 +24V 100n
C12 0 +24V 100n
C35 +24V 0 220u
C19 +24V 0 220u
C95 +24V 0 1000u
R51 /NET0032 /+24VF 33k
C52 0 +24V 10u
C38 0 +24V 100n
R38 NET0031 +3V3 2.2k
R55 NET0027 +3V3 2.2k
R24 Net-_M3A-TX1/IO22_ NET0036 1k
C74 /NET0048 /0ISOEC 10n
C42 /NET0048 /0ISOEC 100n
R1 /NET0046 /NET0048 2.2k
R32 /NET0029 /NET0048 2.2k
R19 /NET0064 /NET0048 16.9k
C77 0 +3V3 100n
C79 0 +3V3 10u
C55 /0ISOEC /NET0033 100n
C1 /0ISOEC /NET0033 10u
C89 0 +5V 10u
R6 8BK +5V 52.3k
R37 0 8BK 10k
C50 +5V 0 220u
C6 0 +5V 10u
C13 0 +5V 10u
C57 0 +3V3 22u
C8 /NET0050 /0ISOpH 100n
C20 /0ISOpH /NET0018 10u
R50 /NET0043 /NET0050 2.2k
R42 /NET0059 /NET0050 2.2k
C17 0 +3V3 100n
C44 0 +3V3 10u
R36 /NET0064 /0ISOEC 10k
C14 0 +3V3 10u
C82 +3V3 0 10n
C39 0 +3V3 100n
C84 +3V3 0 100n
L2 /+5VBK +5V 10u
C63 /NET0073 /+5VBK 100n
C41 0 /NET0057 33n
R5 0 /NET0013 21k
R34 /NET0053 /0ISOpH 10k
R25 /NET0053 /NET0050 16.9k
C76 /NET0050 /0ISOpH 10n
C31 /0ISOpH /NET0018 100n
C70 +3V3 0 100n
C54 +3V3 0 10n
C7 0 +3V3 100n
C18 0 +3V3 10u
C73 0 NA 2.2u
R9 0 /VREFNA 10.7k
R54 /VREFNA NA 14k
C34 0 +24V 100n
C60 0 +24V 100n
C43 /NET0094 +24V 100n
C80 /NET0030 /NET0042 22n
C65 0 +3V3 100n
R48 /NET0098 0 110m
R40 /NET0012 0 110m
R41 /VREFNB NB 14k
C40 0 NB 2.2u
R11 0 /VREFNB 10.7k
R2 /NET0089 0 110m
R46 /NET0004 0 110m

V_24V +24V 0 DC 24.0
V_3V3 +3V3 0 DC 3.3
V_5V +5V 0 DC 5.0

.control
tran 100u 10m
set filetype=ascii
write OPNhydro_r2_raw.raw all
.endc

.end
