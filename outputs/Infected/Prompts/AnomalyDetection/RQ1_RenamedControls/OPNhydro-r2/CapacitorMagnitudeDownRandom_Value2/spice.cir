.title KiCad schematic

C56 0 +24V 100n
C16 0 +3V3 10u
C67 0 +3V3 100n
C95 NET0050 +3V3 100n
R22 NET0046 +3V3 10k
R8 0 NET0050 10k
C75 0 NET0046 100n
C47 +5V 0 100u
R6 NET0012 /NET0024 100
R54 0 /NET0024 10k
C30 0 +24V 100n
C28 +24V 0 47u
R15 NET0046 /NET0052 4.7k
R45 NET0050 /NET0007 4.7k
R35 NET0081 /NET0094 100
C65 +24V 0 220u
R14 /NET0094 +3V3 10k
C74 0 +3V3 100n
C61 /NET0083 /NET0048 22n
C49 0 pH 2.2u
C12 0 +3V3 100n
C25 +24V 0 220u
R44 0 /VREFpH 10.7k
R46 /VREFpH pH 14k
C50 /NET0040 +24V 100n
C92 /NET0036 /NET0035 22n
C9 0 +24V 100n
C64 0 +24V 100n
R9 /NET0059 0 110m
R17 /NET0057 0 110m
C48 0 +24V 100n
C69 /NET0038 +24V 100n
C77 0 +24V 100n
C37 +24V 0 220u
C39 +24V 0 220u
C32 +24V 0 1000u
R1 /NET0004 /+24VF 33k
C80 0 +24V 10u
C78 0 +24V 100n
R7 NET0042 +3V3 2.2k
R27 NET0098 +3V3 2.2k
R30 Net-_M4A-TX1/IO22_ NET0031 1k
C86 /NET0064 /0ISOEC 10n
C31 /NET0064 /0ISOEC 100n
R36 /NET0013 /NET0064 2.2k
R13 /NET0026 /NET0064 2.2k
R11 /NET0087 /NET0064 16.9k
C27 0 +3V3 100n
C60 0 +3V3 10u
C84 /0ISOEC /NET0010 100n
C58 /0ISOEC /NET0010 10u
C42 0 +5V 10u
R37 8BK +5V 52.3k
R25 0 8BK 10k
C41 +5V 0 220u
C3 0 +5V 10u
C90 0 +5V 10u
C40 0 +3V3 22u
C8 /NET0067 /0ISOpH 100n
C88 /0ISOpH /NET0037 10u
R33 /NET0045 /NET0067 2.2k
R56 /NET0063 /NET0067 2.2k
C14 0 +3V3 100n
C57 0 +3V3 10u
R32 /NET0087 /0ISOEC 10k
C79 0 +3V3 10u
C72 +3V3 0 10n
C7 0 +3V3 100n
C11 +3V3 0 100n
L2 /+5VBK +5V 10u
C66 /NET0096 /+5VBK 100n
C26 0 /NET0055 33n
R42 0 /NET0076 21k
R18 /NET0009 /0ISOpH 10k
R48 /NET0009 /NET0067 16.9k
C20 /NET0067 /0ISOpH 10n
C68 /0ISOpH /NET0037 100n
C94 +3V3 0 100n
C44 +3V3 0 10n
C21 0 +3V3 100n
C24 0 +3V3 10u
C29 0 NA 2.2u
R38 0 /VREFNA 10.7k
R3 /VREFNA NA 14k
C1 0 +24V 100n
C19 0 +24V 100n
C62 /NET0069 +24V 100n
C34 /NET0014 /NET0018 22n
C22 0 +3V3 100n
R28 /NET0092 0 110m
R41 /NET0001 0 110m
R52 /VREFNB NB 14k
C52 0 NB 2.2u
R53 0 /VREFNB 10.7k
R29 /NET0080 0 110m
R21 /NET0008 0 110m

V_24V +24V 0 DC 24.0
V_3V3 +3V3 0 DC 3.3
V_5V +5V 0 DC 5.0

.control
tran 100u 10m
set filetype=ascii
write OPNhydro_r2_raw.raw all
.endc

.end
