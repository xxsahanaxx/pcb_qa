.title KiCad schematic

C11 0 +24V 100n
C36 0 +3V3 10u
C67 0 +3V3 100n
C37 NET0038 +3V3 100n
R26 NET0009 +3V3 10k
R54 0 NET0038 10k
C33 0 NET0009 100n
C25 +5V 0 100u
R21 NET0057 /NET0070 100
R49 0 /NET0070 10k
C87 0 +24V 100n
C90 +24V 0 47u
R11 NET0009 /NET0028 4.7k
R50 NET0038 /NET0087 4.7k
R6 NET0005 /NET0042 100
C7 +24V 0 220u
R7 /NET0042 +3V3 10k
C15 0 +3V3 100n
C5 /NET0050 /NET0090 22n
C63 0 pH 2.2u
C26 0 +3V3 100n
C34 +24V 0 220u
R53 0 /VREFpH 10.7k
R42 /VREFpH pH 14k
C56 /NET0085 +24V 100n
C76 /NET0093 /NET0074 22n
C39 0 +24V 100n
C41 0 +24V 100n
R8 /NET0081 0 110m
R31 /NET0077 0 110m
C68 0 +24V 100n
C59 /NET0083 +24V 100n
C20 0 +24V 100n
C73 +24V 0 220u
C38 +24V 0 220u
C12 +24V 0 1000u
R9 /NET0017 /+24VF 33k
C91 0 +24V 10u
C71 0 +24V 100n
R52 NET0060 +3V3 2.2k
R51 NET0008 +3V3 2.2k
R16 Net-_M4A-TX1/IO22_ NET0035 1k
C17 /NET0092 /0ISOEC 10n
C95 /NET0092 /0ISOEC 100n
R23 /NET0024 /NET0092 2.2k
R41 /NET0003 /NET0092 2.2k
R30 /NET0019 /NET0092 16.9k
C45 0 +3V3 100n
C42 0 +3V3 10u
C72 /0ISOEC /NET0065 100n
C70 /0ISOEC /NET0065 10u
C94 0 +5V 10u
R28 8BK +5V 52.3k
R36 0 8BK 10k
C54 +5V 0 220u
C57 0 +5V 10u
C79 0 +5V 10u
C58 0 +3V3 22u
C21 /NET0037 /0ISOpH 100n
C93 /0ISOpH /NET0053 10u
R2 /NET0063 /NET0037 2.2k
R33 /NET0061 /NET0037 2.2k
C48 0 +3V3 100n
C92 0 +3V3 10u
R48 /NET0019 /0ISOEC 10k
C3 0 +3V3 10u
C86 +3V3 0 10n
C18 0 +3V3 100n
C13 +3V3 0 100n
L2 /+5VBK +5V 10u
C14 /NET0051 /+5VBK 100n
C46 0 /NET0036 33n
R19 0 /NET0027 21k
R4 /NET0023 /0ISOpH 10k
R46 /NET0023 /NET0037 16.9k
C81 /NET0037 /0ISOpH 10n
C60 /0ISOpH /NET0053 100n
C22 +3V3 0 100n
C6 +3V3 0 10n
C43 0 +3V3 100n
C19 0 +3V3 10u
C80 0 NA 2.2u
R17 0 /VREFNA 10.7k
R35 /VREFNA NA 14k
C64 0 +24V 100n
C65 0 +24V 100n
C82 /NET0034 +24V 100n
C83 /NET0052 /NET0015 22n
C16 0 +3V3 100n
R24 /NET0021 0 110m
R18 /NET0046 0 110m
R55 /VREFNB NB 14k
C66 0 NB 2.2u
R1 0 /VREFNB 10.7k
R25 /NET0064 0 110m
R37 /NET0041 0 110m

V_24V +24V 0 DC 24.0
V_3V3 +3V3 0 DC 3.3
V_5V +5V 0 DC 5.0

.control
tran 100u 10m
set filetype=ascii
write OPNhydro_r2_raw.raw all
.endc

.end
