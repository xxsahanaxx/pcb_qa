.title KiCad schematic

C47 0 +24V 100n
C57 0 +3V3 10u
C88 0 +3V3 100n
C49 NET0056 +3V3 100n
R3 NET0024 +3V3 10k
R5 0 NET0056 10k
C23 0 NET0024 100n
C56 +5V 0 100u
R47 NET0009 /NET0088 100
R8 0 /NET0088 10k
C33 0 +24V 100n
C75 +24V 0 47u
R23 NET0024 /NET0001 4.7k
R26 NET0056 /NET0084 4.7k
R16 NET0012 /NET0068 100
C60 +24V 0 220u
R11 /NET0068 +3V3 10k
C39 0 +3V3 100n
C37 /NET0074 /NET0069 22n
C25 0 pH 2.2u
C67 0 +3V3 100n
C93 +24V 0 220u
R31 0 /VREFpH 10.7k
R33 /VREFpH pH 14k
C32 /NET0039 +24V 100n
C80 /NET0063 /NET0023 22n
C21 0 +24V 100n
C65 0 +24V 100n
R4 /NET0043 0 110m
R37 /NET0075 0 110m
C10 0 +24V 100n
C59 /NET0093 +24V 100n
C36 0 +24V 100n
C90 +24V 0 220u
C91 +24V 0 220u
C79 +24V 0 1000u
R49 /NET0055 /+24VF 33k
C26 0 +24V 10u
C28 0 +24V 100n
R10 NET0033 +3V3 2.2k
R55 NET0057 +3V3 2.2k
R34 Net-_M4A-TX1/IO22_ NET0020 1k
C87 /NET0041 /0ISOEC 10n
C6 /NET0041 /0ISOEC 100n
R25 /NET0052 /NET0041 2.2k
R46 /NET0006 /NET0041 2.2k
R39 /NET0028 /NET0041 16.9k
C71 0 +3V3 100n
C18 0 +3V3 10u
C73 /0ISOEC /NET0005 100n
C4 /0ISOEC /NET0005 10u
C85 0 +5V 10u
R22 8BK +5V 52.3k
R48 0 8BK 10k
C76 +5V 0 220u
C7 0 +5V 10u
C27 0 +5V 10u
C51 0 +3V3 22u
C74 /NET0002 /0ISOpH 100n
C20 /0ISOpH /NET0040 10u
R45 /NET0098 /NET0002 2.2k
R36 /NET0014 /NET0002 2.2k
C22 0 +3V3 100n
C46 0 +3V3 10u
R32 /NET0028 /0ISOEC 10k
C44 0 +3V3 10u
C12 +3V3 0 10n
C58 0 +3V3 100n
C41 +3V3 0 100n
L2 /+5VBK +5V 10u
C70 /NET0067 /+5VBK 100n
C95 0 /NET0072 33n
R38 0 /NET0061 21k
R1 /NET0081 /0ISOpH 10k
R50 /NET0081 /NET0002 16.9k
C77 /NET0002 /0ISOpH 10n
C83 /0ISOpH /NET0040 100n
C63 +3V3 0 100n
C5 +3V3 0 10n
C81 0 +3V3 100n
C45 0 +3V3 10u
C30 0 NA 2.2u
R40 0 /VREFNA 10.7k
R35 /VREFNA NA 14k
C35 0 +24V 100n
C64 0 +24V 100n
C61 /NET0018 +24V 100n
C50 /NET0053 /NET0037 22n
C38 0 +3V3 100n
R13 /NET0079 0 110m
R15 /NET0027 0 110m
R44 /VREFNB NB 14k
C62 0 NB 2.2u
R43 0 /VREFNB 10.7k
R21 /NET0022 0 110m
R52 /NET0059 0 110m

V_24V +24V 0 DC 24.0
V_3V3 +3V3 0 DC 3.3
V_5V +5V 0 DC 5.0

.control
tran 100u 10m
set filetype=ascii
write OPNhydro_r2_raw.raw all
.endc

.end
