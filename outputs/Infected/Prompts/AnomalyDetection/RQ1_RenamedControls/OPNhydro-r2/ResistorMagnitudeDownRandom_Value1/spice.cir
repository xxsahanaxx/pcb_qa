.title KiCad schematic

C62 0 +24V 100n
C81 0 +3V3 10u
C15 0 +3V3 100n
C71 NET0095 +3V3 100n
R26 NET0038 +3V3 10k
R3 0 NET0095 10k
C68 0 NET0038 100n
C17 +5V 0 100u
R29 NET0025 /NET0090 100
R33 0 /NET0090 10k
C3 0 +24V 100n
C69 +24V 0 47u
R19 NET0038 /NET0037 4.7k
R25 NET0095 /NET0053 4.7k
R14 NET0007 /NET0061 100
C32 +24V 0 220u
R7 /NET0061 +3V3 10k
C84 0 +3V3 100n
C31 /NET0013 /NET0072 22n
C60 0 pH 2.2u
C92 0 +3V3 100n
C2 +24V 0 220u
R6 0 /VREFpH 10.7k
R36 /VREFpH pH 14k
C85 /NET0023 +24V 100n
C30 /NET0060 /NET0008 22n
C44 0 +24V 100n
C18 0 +24V 100n
R49 /NET0040 0 110m
R1 /NET0010 0 110m
C49 0 +24V 100n
C65 /NET0073 +24V 100n
C50 0 +24V 100n
C9 +24V 0 220u
C33 +24V 0 220u
C73 +24V 0 1000u
R2 /NET0062 /+24VF 33k
C67 0 +24V 10u
C12 0 +24V 100n
R44 NET0081 +3V3 2.2k
R50 NET0020 +3V3 2.2k
R55 Net-_M2A-TX1/IO22_ NET0015 1k
C34 /NET0028 /0ISOEC 10n
C55 /NET0028 /0ISOEC 100n
R56 /NET0070 /NET0028 2.2k
R48 /NET0089 /NET0028 2.2k
R30 /NET0029 /NET0028 16.9k
C48 0 +3V3 100n
C95 0 +3V3 10u
C54 /0ISOEC /NET0048 100n
C46 /0ISOEC /NET0048 10u
C72 0 +5V 10u
R5 8BK +5V 52.3k
R13 0 8BK 10k
C75 +5V 0 220u
C57 0 +5V 10u
C64 0 +5V 10u
C40 0 +3V3 22u
C53 /NET0076 /0ISOpH 100n
C59 /0ISOpH /NET0001 10u
R42 /NET0065 /NET0076 2.2k
R45 /NET0027 /NET0076 2.2k
C7 0 +3V3 100n
C23 0 +3V3 10u
R54 /NET0029 /0ISOEC 10k
C51 0 +3V3 10u
C76 +3V3 0 10n
C96 0 +3V3 100n
C74 +3V3 0 100n
L2 /+5VBK +5V 10u
C43 /NET0080 /+5VBK 100n
C8 0 /NET0055 33n
R41 0 /NET0050 21k
R18 /NET0035 /0ISOpH 10k
R23 /NET0035 /NET0076 16.9k
C4 /NET0076 /0ISOpH 10n
C5 /0ISOpH /NET0001 100n
C70 +3V3 0 100n
C13 +3V3 0 10n
C66 0 +3V3 100n
C35 0 +3V3 10u
C1 0 NA 2.2u
R28 0 /VREFNA 10.7k
R31 /VREFNA NA 14k
C24 0 +24V 100n
C36 0 +24V 100n
C56 /NET0067 +24V 100n
C91 /NET0031 /NET0074 22n
C80 0 +3V3 100n
R40 /NET0082 0 110m
R11 /NET0049 0 110m
R53 /VREFNB NB 14k
C20 0 NB 2.2u
R46 0 /VREFNB 10.7k
R8 /NET0034 0 110m
R52 /NET0054 0 110m

V_24V +24V 0 DC 24.0
V_3V3 +3V3 0 DC 3.3
V_5V +5V 0 DC 5.0

.control
tran 100u 10m
set filetype=ascii
write OPNhydro_r2_raw.raw all
.endc

.end
