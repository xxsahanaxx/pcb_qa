.title KiCad schematic

C65 0 +24V 100n
C49 0 +3V3 10u
C78 0 +3V3 100n
C96 NET0099 +3V3 100n
R20 NET0063 +3V3 10k
R25 0 NET0099 10k
C61 0 NET0063 100n
C64 +5V 0 100u
R5 NET0021 /NET0029 100
R13 0 /NET0029 10k
C31 0 +24V 100n
C12 +24V 0 47u
R12 NET0063 /NET0024 4.7k
R45 NET0099 /NET0064 4.7k
R39 NET0094 /NET0027 100
C83 +24V 0 220u
R22 /NET0027 +3V3 10k
C13 0 +3V3 100n
C89 /NET0084 /NET0098 22n
C11 0 pH 2.2u
C10 0 +3V3 100n
C74 +24V 0 220u
R55 0 /VREFpH 10.7k
R43 /VREFpH pH 14k
C91 /NET0069 +24V 100n
C63 /NET0013 /NET0039 22n
C36 0 +24V 100n
C5 0 +24V 100n
R53 /NET0081 0 110m
R17 /NET0086 0 110m
C7 0 +24V 100n
C25 /NET0015 +24V 100n
C66 0 +24V 100n
C76 +24V 0 220u
C35 +24V 0 220u
C22 +24V 0 1000u
R54 /NET0079 /+24VF 33k
C51 0 +24V 10u
C4 0 +24V 100n
R19 NET0020 +3V3 2.2k
R44 NET0014 +3V3 2.2k
R30 Net-_M2A-TX1/IO22_ NET0056 1k
C93 /NET0087 /0ISOEC 10n
C54 /NET0087 /0ISOEC 100n
R1 /NET0060 /NET0087 2.2k
R42 /NET0045 /NET0087 2.2k
R34 /NET0043 /NET0087 16.9k
C57 0 +3V3 100n
C75 0 +3V3 10u
C34 /0ISOEC /NET0044 100n
C39 /0ISOEC /NET0044 10u
C60 0 +5V 10u
R9 8BK +5V 52.3k
R51 0 8BK 10k
C28 +5V 0 220u
C14 0 +5V 10u
C86 0 +5V 10u
C44 0 +3V3 22u
C85 /NET0061 /0ISOpH 100n
C1 /0ISOpH /NET0012 10u
R26 /NET0076 /NET0061 2.2k
R50 /NET0037 /NET0061 2.2k
C30 0 +3V3 100n
C33 0 +3V3 10u
R28 /NET0043 /0ISOEC 10k
C56 0 +3V3 10u
C29 +3V3 0 10n
C95 0 +3V3 100n
C26 +3V3 0 100n
L2 /+5VBK +5V 10u
C24 /NET0038 /+5VBK 100n
C77 0 /NET0010 33n
R31 0 /NET0071 21k
R23 /NET0033 /0ISOpH 10k
R27 /NET0033 /NET0061 16.9k
C92 /NET0061 /0ISOpH 10n
C45 /0ISOpH /NET0012 100n
C69 +3V3 0 100n
C3 +3V3 0 10n
C21 0 +3V3 100n
C58 0 +3V3 10u
C72 0 NA 2.2u
R3 0 /VREFNA 10.7k
R33 /VREFNA NA 14k
C70 0 +24V 100n
C9 0 +24V 100n
C18 /NET0007 +24V 100n
C59 /NET0062 /NET0042 22n
C19 0 +3V3 100n
R48 /NET0077 0 110m
R36 /NET0009 0 110m
R37 /VREFNB NB 14k
C6 0 NB 2.2u
R46 0 /VREFNB 10.7k
R2 /NET0040 0 110m
R47 /NET0023 0 110m

V_24V +24V 0 DC 24.0
V_3V3 +3V3 0 DC 3.3
V_5V +5V 0 DC 5.0

.control
tran 100u 10m
set filetype=ascii
write OPNhydro_r2_raw.raw all
.endc

.end
