.title KiCad schematic

C88 0 +24V 100n
C57 0 +3V3 10u
C70 0 +3V3 100n
C68 NET0060 +3V3 100n
R28 NET0035 +3V3 10k
R46 0 NET0060 10k
C45 0 NET0035 100n
C54 +5V 0 100u
R36 NET0016 /NET0014 100
R31 0 /NET0014 10k
C3 0 +24V 100n
C56 +24V 0 47u
R53 NET0035 /NET0044 4.7k
R48 NET0060 /NET0082 4.7k
R26 NET0011 /NET0056 100
C55 +24V 0 220u
R8 /NET0056 +3V3 10k
C34 0 +3V3 100n
C63 /NET0031 /NET0022 22n
C50 0 pH 2.2u
C92 0 +3V3 100n
C17 +24V 0 220u
R49 0 /VREFpH 10.7k
R14 /VREFpH pH 14k
C27 /NET0028 +24V 100n
C84 /NET0032 /NET0088 22n
C9 0 +24V 100n
C77 0 +24V 100n
R10 /NET0073 0 110m
R54 /NET0071 0 110m
C66 0 +24V 100n
C91 /NET0048 +24V 100n
C95 0 +24V 100n
C8 +24V 0 220u
C78 +24V 0 220u
C52 +24V 0 1000u
R19 /NET0062 /+24VF 33k
C42 0 +24V 10u
C86 0 +24V 100n
R16 NET0069 +3V3 2.2k
R5 NET0086 +3V3 2.2k
R43 Net-_M6A-TX1/IO22_ NET0029 1k
C14 /NET0040 /0ISOEC 10n
C41 /NET0040 /0ISOEC 100n
R44 /NET0043 /NET0040 2.2k
R34 /NET0034 /NET0040 2.2k
R41 /NET0004 /NET0040 16.9k
C5 0 +3V3 100n
C82 0 +3V3 10u
C67 /0ISOEC /NET0017 100n
C80 /0ISOEC /NET0017 10u
C81 0 +5V 10u
R55 8BK +5V 52.3k
R32 0 8BK 10k
C90 +5V 0 220u
C96 0 +5V 10u
C18 0 +5V 10u
C76 0 +3V3 22u
C20 /NET0064 /0ISOpH 100n
C19 /0ISOpH /NET0003 10u
R47 /NET0097 /NET0064 2.2k
R15 /NET0098 /NET0064 2.2k
C48 0 +3V3 100n
C13 0 +3V3 10u
R1 /NET0004 /0ISOEC 10k
C69 0 +3V3 10u
C12 +3V3 0 10n
C6 0 +3V3 100n
C31 +3V3 0 100n
L2 /+5VBK +5V 10u
C32 /NET0010 /+5VBK 100n
C53 0 /NET0085 33n
R21 0 /NET0041 21k
R38 /NET0076 /0ISOpH 10k
R30 /NET0076 /NET0064 16.9k
C83 /NET0064 /0ISOpH 10n
C43 /0ISOpH /NET0003 100n
C1 +3V3 0 100n
C46 +3V3 0 10n
C7 0 +3V3 100n
C35 0 +3V3 10u
C29 0 NA 2.2u
R56 0 /VREFNA 10.7k
R7 /VREFNA NA 14k
C73 0 +24V 100n
C10 0 +24V 100n
C36 /NET0030 +24V 100n
C39 /NET0075 /NET0013 22n
C47 0 +3V3 100n
R11 /NET0083 0 110m
R17 /NET0023 0 110m
R39 /VREFNB NB 14k
C64 0 NB 2.2u
R6 0 /VREFNB 10.7k
R2 /NET0039 0 110m
R42 /NET0038 0 110m

V_24V +24V 0 DC 24.0
V_3V3 +3V3 0 DC 3.3
V_5V +5V 0 DC 5.0

.control
tran 100u 10m
set filetype=ascii
write OPNhydro_r2_raw.raw all
.endc

.end
