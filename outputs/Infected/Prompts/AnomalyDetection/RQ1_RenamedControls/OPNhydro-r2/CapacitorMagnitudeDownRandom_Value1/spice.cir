.title KiCad schematic

C72 0 +24V 100n
C93 0 +3V3 10u
C5 0 +3V3 100n
C3 NET0032 +3V3 100n
R54 NET0076 +3V3 10k
R11 0 NET0032 10k
C63 0 NET0076 100n
C71 +5V 0 100u
R53 NET0087 /NET0074 100
R29 0 /NET0074 10k
C70 0 +24V 100n
C28 +24V 0 47u
R33 NET0076 /NET0002 4.7k
R8 NET0032 /NET0012 4.7k
R3 NET0077 /NET0078 100
C95 +24V 0 220u
R45 /NET0078 +3V3 10k
C94 0 +3V3 100n
C79 /NET0081 /NET0099 22n
C29 0 pH 2.2u
C51 0 +3V3 100n
C4 +24V 0 220u
R22 0 /VREFpH 10.7k
R16 /VREFpH pH 14k
C25 /NET0016 +24V 100n
C80 /NET0095 /NET0036 22n
C90 0 +24V 100n
C57 0 +24V 100n
R27 /NET0006 0 110m
R6 /NET0031 0 110m
C6 0 +24V 100n
C8 /NET0066 +24V 100n
C20 0 +24V 100n
C39 +24V 0 220u
C84 +24V 0 220u
C61 +24V 0 1000u
R40 /NET0045 /+24VF 33k
C62 0 +24V 10u
C68 0 +24V 100n
R20 NET0056 +3V3 2.2k
R13 NET0019 +3V3 2.2k
R15 Net-_M3A-TX1/IO22_ NET0080 1k
C24 /NET0060 /0ISOEC 10n
C12 /NET0060 /0ISOEC 100n
R14 /NET0059 /NET0060 2.2k
R39 /NET0011 /NET0060 2.2k
R9 /NET0050 /NET0060 16.9k
C18 0 +3V3 100n
C10 0 +3V3 10u
C36 /0ISOEC /NET0089 100n
C15 /0ISOEC /NET0089 10u
C87 0 +5V 10u
R28 8BK +5V 52.3k
R47 0 8BK 10k
C78 +5V 0 220u
C89 0 +5V 10u
C38 0 +5V 10u
C66 0 +3V3 22u
C13 /NET0063 /0ISOpH 100n
C21 /0ISOpH /NET0015 10u
R37 /NET0093 /NET0063 2.2k
R50 /NET0046 /NET0063 2.2k
C56 0 +3V3 100n
C42 0 +3V3 10u
R34 /NET0050 /0ISOEC 10k
C26 0 +3V3 10u
C82 +3V3 0 10n
C44 0 +3V3 100n
C43 +3V3 0 100n
L2 /+5VBK +5V 10u
C75 /NET0039 /+5VBK 100n
C45 0 /NET0037 33n
R41 0 /NET0021 21k
R36 /NET0033 /0ISOpH 10k
R10 /NET0033 /NET0063 16.9k
C35 /NET0063 /0ISOpH 10n
C16 /0ISOpH /NET0015 100n
C52 +3V3 0 100n
C58 +3V3 0 10n
C41 0 +3V3 100n
C1 0 +3V3 10u
C40 0 NA 2.2u
R26 0 /VREFNA 10.7k
R30 /VREFNA NA 14k
C14 0 +24V 100n
C50 0 +24V 100n
C83 /NET0029 +24V 100n
C76 /NET0047 /NET0049 22n
C81 0 +3V3 100n
R43 /NET0075 0 110m
R48 /NET0058 0 110m
R46 /VREFNB NB 14k
C59 0 NB 2.2u
R4 0 /VREFNB 10.7k
R1 /NET0072 0 110m
R23 /NET0053 0 110m

V_24V +24V 0 DC 24.0
V_3V3 +3V3 0 DC 3.3
V_5V +5V 0 DC 5.0

.control
tran 100u 10m
set filetype=ascii
write OPNhydro_r2_raw.raw all
.endc

.end
