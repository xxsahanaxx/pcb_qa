.title KiCad schematic

C29 0 +24V 100n
C68 0 +3V3 10u
C5 0 +3V3 100n
C47 NET0046 +3V3 100n
R17 NET0024 +3V3 10k
R38 0 NET0046 10k
C59 0 NET0024 100n
C62 +5V 0 100u
R18 NET0070 /NET0097 100
R24 0 /NET0097 10k
C74 0 +24V 100n
C53 +24V 0 47u
R52 NET0024 /NET0027 4.7k
R14 NET0046 /NET0038 4.7k
R28 NET0048 /NET0096 100
C23 +24V 0 220u
R36 /NET0096 +3V3 10k
C58 0 +3V3 100n
C43 /NET0052 /NET0053 22n
C4 0 pH 2.2u
C11 0 +3V3 100n
C91 +24V 0 220u
R46 0 /VREFpH 10.7k
R6 /VREFpH pH 14k
C20 /NET0007 +24V 100n
C41 /NET0061 /NET0081 22n
C44 0 +24V 100n
C36 0 +24V 100n
R16 /NET0045 0 110m
R39 /NET0042 0 110m
C60 0 +24V 100n
C56 /NET0086 +24V 100n
C10 0 +24V 100n
C37 +24V 0 220u
C93 +24V 0 220u
C15 +24V 0 1000u
R13 /NET0069 /+24VF 33k
C45 0 +24V 10u
C27 0 +24V 100n
R31 NET0022 +3V3 2.2k
R54 NET0090 +3V3 2.2k
R27 Net-_M6A-TX1/IO22_ NET0033 1k
C89 /NET0004 /0ISOEC 10n
C55 /NET0004 /0ISOEC 100n
R8 /NET0029 /NET0004 2.2k
R37 /NET0068 /NET0004 2.2k
R30 /NET0085 /NET0004 16.9k
C90 0 +3V3 100n
C16 0 +3V3 10u
C86 /0ISOEC /NET0076 100n
C77 /0ISOEC /NET0076 10u
C39 0 +5V 10u
R48 8BK +5V 52.3k
R50 0 8BK 10k
C21 +5V 0 220u
C73 0 +5V 10u
C2 0 +5V 10u
C81 0 +3V3 22u
C46 /NET0073 /0ISOpH 100n
C87 /0ISOpH /NET0009 10u
R33 /NET0067 /NET0073 2.2k
R15 /NET0088 /NET0073 2.2k
C48 0 +3V3 100n
C88 0 +3V3 10u
R9 /NET0085 /0ISOEC 10k
C70 0 +3V3 10u
C61 +3V3 0 10n
C95 0 +3V3 100n
C83 +3V3 0 100n
L2 /+5VBK +5V 10u
C82 /NET0037 /+5VBK 100n
C12 0 /NET0095 33n
R42 0 /NET0074 21k
R43 /NET0089 /0ISOpH 10k
R56 /NET0089 /NET0073 16.9k
C40 /NET0073 /0ISOpH 10n
C8 /0ISOpH /NET0009 100n
C3 +3V3 0 100n
C32 +3V3 0 10n
C80 0 +3V3 100n
C25 0 +3V3 10u
C31 0 NA 2.2u
R45 0 /VREFNA 10.7k
R12 /VREFNA NA 14k
C94 0 +24V 100n
C57 0 +24V 100n
C18 /NET0013 +24V 100n
C51 /NET0017 /NET0080 22n
C33 0 +3V3 100n
R49 /NET0023 0 110m
R47 /NET0011 0 110m
R21 /VREFNB NB 14k
C66 0 NB 2.2u
R22 0 /VREFNB 10.7k
R7 /NET0051 0 110m
R51 /NET0018 0 110m

V_24V +24V 0 DC 24.0
V_3V3 +3V3 0 DC 3.3
V_5V +5V 0 DC 5.0

.control
tran 100u 10m
set filetype=ascii
write OPNhydro_r2_raw.raw all
.endc

.end
