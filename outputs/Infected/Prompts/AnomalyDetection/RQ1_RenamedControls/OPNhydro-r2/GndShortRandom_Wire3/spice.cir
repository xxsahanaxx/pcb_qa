.title KiCad schematic

C70 0 +24V 100n
C48 0 +3V3 10u
C8 0 +3V3 100n
C36 NET0060 +3V3 100n
R30 NET0044 +3V3 10k
R25 0 NET0060 10k
C6 0 NET0044 100n
C12 +5V 0 100u
R53 NET0048 /NET0081 100
R38 0 /NET0081 10k
C4 0 +24V 100n
C46 +24V 0 47u
R5 NET0044 /NET0061 4.7k
R2 NET0060 /NET0083 4.7k
R7 NET0032 /NET0089 100
C7 +24V 0 220u
R26 /NET0089 +3V3 10k
C75 0 +3V3 100n
C51 /NET0065 /NET0056 22n
C5 0 pH 2.2u
C11 0 +3V3 100n
C30 +24V 0 220u
R14 0 /VREFpH 10.7k
R35 /VREFpH pH 14k
C82 /NET0058 +24V 100n
C88 /NET0015 /NET0076 22n
C44 0 +24V 100n
C52 0 +24V 100n
R6 /NET0072 0 110m
R45 /NET0014 0 110m
C93 0 +24V 100n
C38 /NET0057 +24V 100n
C77 0 +24V 100n
C65 +24V 0 220u
C59 +24V 0 220u
C53 +24V 0 1000u
R48 /NET0097 /+24VF 33k
C72 0 +24V 10u
C9 0 +24V 100n
R36 NET0051 +3V3 2.2k
R33 NET0046 +3V3 2.2k
R54 Net-_M2A-TX1/IO22_ NET0092 1k
C56 /NET0042 /0ISOEC 10n
C80 /NET0042 /0ISOEC 100n
R21 /NET0075 /NET0042 2.2k
R32 /NET0012 /NET0042 2.2k
R28 /NET0028 /NET0042 16.9k
C10 0 +3V3 100n
C66 0 +3V3 10u
C54 /0ISOEC /NET0063 100n
C96 /0ISOEC /NET0063 10u
C13 0 +5V 10u
R13 8BK +5V 52.3k
R11 0 8BK 10k
C84 +5V 0 220u
C24 0 +5V 10u
C69 0 +5V 10u
C86 0 +3V3 22u
C81 /NET0053 /0ISOpH 100n
C91 /0ISOpH /NET0045 10u
R42 /NET0091 /NET0053 2.2k
R39 /NET0008 /NET0053 2.2k
C1 0 +3V3 100n
C19 0 +3V3 10u
R22 /NET0028 /0ISOEC 10k
C15 0 +3V3 10u
C64 +3V3 0 10n
C39 0 +3V3 100n
C94 +3V3 0 100n
L2 /+5VBK +5V 10u
C79 /NET0037 /+5VBK 100n
C57 0 /NET0027 33n
R24 0 /NET0052 21k
R19 /NET0067 /0ISOpH 10k
R56 /NET0067 /NET0053 16.9k
C27 /NET0053 /0ISOpH 10n
C58 /0ISOpH /NET0045 100n
C76 +3V3 0 100n
C67 +3V3 0 10n
C14 0 +3V3 100n
C3 0 +3V3 10u
C26 0 NA 2.2u
R46 0 /VREFNA 10.7k
R8 /VREFNA NA 14k
C35 0 +24V 100n
C78 0 +24V 100n
C95 /NET0001 +24V 100n
C32 /NET0011 /NET0068 22n
C55 0 +3V3 100n
R52 /NET0013 0 110m
R51 /NET0004 0 110m
R10 /VREFNB NB 14k
C29 0 NB 2.2u
R17 0 /VREFNB 10.7k
R34 /NET0087 0 110m
R37 /NET0047 0 110m

V_24V +24V 0 DC 24.0
V_3V3 +3V3 0 DC 3.3
V_5V +5V 0 DC 5.0

.control
tran 100u 10m
set filetype=ascii
write OPNhydro_r2_raw.raw all
.endc

.end
