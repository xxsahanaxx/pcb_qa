.title KiCad schematic

C93 0 +24V 100n
C90 0 +3V3 10u
C38 0 +3V3 100n
C74 NET0008 +3V3 100n
R42 NET0089 +3V3 10k
R53 0 NET0008 10k
C10 0 NET0089 100n
C52 +5V 0 100u
R49 NET0061 /NET0031 100
R34 0 /NET0031 10k
C85 0 +24V 100n
C73 +24V 0 47u
R28 NET0089 /NET0007 4.7k
R3 NET0008 /NET0064 4.7k
R39 NET0022 /NET0009 100
C11 +24V 0 220u
R18 /NET0009 +3V3 10k
C36 0 +3V3 100n
C45 /NET0060 /NET0066 22n
C46 0 pH 2.2u
C47 0 +3V3 100n
C8 +24V 0 220u
R8 0 /VREFpH 10.7k
R15 /VREFpH pH 14k
C34 /NET0062 +24V 100n
C24 /NET0004 /NET0097 22n
C9 0 +24V 100n
C32 0 +24V 100n
R14 /NET0025 0 110m
R5 /NET0019 0 110m
C4 0 +24V 100n
C69 /NET0051 +24V 100n
C56 0 +24V 100n
C1 +24V 0 220u
C26 +24V 0 220u
C18 +24V 0 1000u
R29 /NET0065 /+24VF 33k
C80 0 +24V 10u
C19 0 +24V 100n
R40 NET0016 +3V3 2.2k
R22 NET0063 +3V3 2.2k
R45 Net-_M3A-TX1/IO22_ NET0049 1k
C33 /NET0014 /0ISOEC 10n
C92 /NET0014 /0ISOEC 100n
R44 /NET0027 /NET0014 2.2k
R41 /NET0050 /NET0014 2.2k
R46 /NET0057 /NET0014 16.9k
C50 0 +3V3 100n
C48 0 +3V3 10u
C40 /0ISOEC /NET0043 100n
C27 /0ISOEC /NET0043 10u
C39 0 +5V 10u
R55 8BK +5V 52.3k
R27 0 8BK 10k
C62 +5V 0 220u
C6 0 +5V 10u
C5 0 +5V 10u
C55 0 +3V3 22u
C31 /NET0040 /0ISOpH 100n
C70 /0ISOpH /NET0071 10u
R50 /NET0053 /NET0040 2.2k
R19 /NET0074 /NET0040 2.2k
C25 0 +3V3 100n
C86 0 +3V3 10u
R32 /NET0057 /0ISOEC 10k
C28 0 +3V3 10u
C87 +3V3 0 10n
C63 0 +3V3 100n
C35 +3V3 0 100n
L2 /+5VBK +5V 10u
C61 /NET0032 /+5VBK 100n
C91 0 /NET0045 33n
R31 0 /NET0068 21k
R48 /NET0098 /0ISOpH 10k
R43 /NET0098 /NET0040 16.9k
C66 /NET0040 /0ISOpH 10n
C82 /0ISOpH /NET0071 100n
C2 +3V3 0 100n
C58 +3V3 0 10n
C53 0 +3V3 100n
C20 0 +3V3 10u
C75 0 NA 2.2u
R17 0 /VREFNA 10.7k
R25 /VREFNA NA 14k
C37 0 +24V 100n
C13 0 +24V 100n
C12 /NET0095 +24V 100n
C83 /NET0001 /NET0042 22n
C49 0 +3V3 100n
R26 /NET0072 0 110m
R16 /NET0021 0 110m
R38 /VREFNB NB 14k
C29 0 NB 2.2u
R12 0 /VREFNB 10.7k
R21 /NET0084 0 110m
R4 /NET0077 0 110m

V_24V +24V 0 DC 24.0
V_3V3 +3V3 0 DC 3.3
V_5V +5V 0 DC 5.0

.control
tran 100u 10m
set filetype=ascii
write OPNhydro_r2_raw.raw all
.endc

.end
