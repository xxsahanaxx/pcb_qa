.title KiCad schematic

R6 NET0008 Net-_Q1-B_ 1k
R2 VCC Net-_Q1-C_ 10k
R8 +5V NET0001 10k
R5 VCC NET0003 10k
C2 VCC 0 100n
C3 +5V 0 100n
R9 /NET0005 NET0008 1k
R1 NET0003 /NET0007 1k

V_5V +5V 0 DC 5.0
V_VCC VCC 0 DC 5.0

.control
tran 100u 10m
set filetype=ascii
write fan_controller_raw.raw all
.endc

.end
