.title KiCad schematic

R9 NET0001 Net-_Q3-B_ 1k
R5 VCC Net-_Q2-G_ 10k
R2 +5V NET0009 10k
R3 VCC NET0003 10k
C2 VCC 0 100n
C1 +5V 0 100n
R7 /NET0007 NET0001 1k
R6 NET0003 /NET0004 1k

V_5V +5V 0 DC 5.0
V_VCC VCC 0 DC 5.0

.control
tran 100u 10m
set filetype=ascii
write fan_controller_raw.raw all
.endc

.end
