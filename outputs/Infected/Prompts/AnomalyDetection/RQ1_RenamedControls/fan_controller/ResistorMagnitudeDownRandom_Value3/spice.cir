.title KiCad schematic

R3 NET0002 Net-_Q3-B_ 1k
R6 VCC Net-_Q2-G_ 10k
R9 +5V NET0004 10k
R8 VCC NET0011 10k
C2 VCC 0 100n
C3 +5V 0 100n
R4 /NET0010 NET0002 1k
R1 NET0011 /NET0005 1k

V_5V +5V 0 DC 5.0
V_VCC VCC 0 DC 5.0

.control
tran 100u 10m
set filetype=ascii
write fan_controller_raw.raw all
.endc

.end
