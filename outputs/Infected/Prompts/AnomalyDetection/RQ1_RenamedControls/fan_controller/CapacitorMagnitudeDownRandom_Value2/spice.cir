.title KiCad schematic

R9 NET0011 Net-_Q1-B_ 1k
R6 VCC Net-_Q1-C_ 10k
R4 +5V NET0012 10k
R8 VCC NET0006 10k
C3 VCC 0 100n
C1 +5V 0 100n
R1 /NET0004 NET0011 1k
R7 NET0006 /NET0007 1k

V_5V +5V 0 DC 5.0
V_VCC VCC 0 DC 5.0

.control
tran 100u 10m
set filetype=ascii
write fan_controller_raw.raw all
.endc

.end
