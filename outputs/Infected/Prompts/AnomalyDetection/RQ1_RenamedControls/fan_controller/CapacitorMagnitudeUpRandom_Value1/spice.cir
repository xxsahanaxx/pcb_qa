.title KiCad schematic

R4 NET0006 Net-_Q3-B_ 1k
R3 VCC Net-_Q2-G_ 10k
R8 +5V NET0005 10k
R2 VCC NET0008 10k
C2 VCC 0 100n
C3 +5V 0 100n
R6 /NET0012 NET0006 1k
R7 NET0008 /NET0001 1k

V_5V +5V 0 DC 5.0
V_VCC VCC 0 DC 5.0

.control
tran 100u 10m
set filetype=ascii
write fan_controller_raw.raw all
.endc

.end
