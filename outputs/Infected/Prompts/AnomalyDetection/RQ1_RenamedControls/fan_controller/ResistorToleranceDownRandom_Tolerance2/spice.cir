.title KiCad schematic

R5 NET0004 Net-_Q1-B_ 1k
R6 VCC Net-_Q1-C_ 10k
R2 +5V NET0009 10k
R1 VCC NET0012 10k
C3 VCC 0 100n
C1 +5V 0 100n
R9 /NET0010 NET0004 1k
R3 NET0012 /NET0005 1k

V_5V +5V 0 DC 5.0
V_VCC VCC 0 DC 5.0

.control
tran 100u 10m
set filetype=ascii
write fan_controller_raw.raw all
.endc

.end
