.title KiCad schematic

R1 NET0007 Net-_Q1-B_ 1k
R9 VCC Net-_Q1-C_ 10k
R2 +5V NET0006 10k
R3 VCC NET0004 10k
C2 VCC 0 100n
C1 +5V 0 100n
R8 /NET0012 NET0007 1k
R6 NET0004 /NET0009 1k

V_5V +5V 0 DC 5.0
V_VCC VCC 0 DC 5.0

.control
tran 100u 10m
set filetype=ascii
write fan_controller_raw.raw all
.endc

.end
