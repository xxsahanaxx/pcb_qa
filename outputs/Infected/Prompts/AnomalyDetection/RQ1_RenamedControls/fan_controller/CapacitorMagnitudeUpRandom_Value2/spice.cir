.title KiCad schematic

R1 NET0009 Net-_Q3-B_ 1k
R4 VCC Net-_Q2-G_ 10k
R7 +5V NET0003 10k
R5 VCC NET0001 10k
C2 VCC 0 100n
C3 +5V 0 100n
R8 /NET0007 NET0009 1k
R9 NET0001 /NET0010 1k

V_5V +5V 0 DC 5.0
V_VCC VCC 0 DC 5.0

.control
tran 100u 10m
set filetype=ascii
write fan_controller_raw.raw all
.endc

.end
