.title KiCad schematic

R7 NET0011 Net-_Q1-B_ 1k
R5 VCC Net-_Q1-C_ 10k
R6 +5V NET0003 10k
R1 VCC NET0008 10k
C3 VCC 0 100n
C1 +5V 0 100n
R2 /NET0009 NET0011 1k
R3 NET0008 /NET0004 1k

V_5V +5V 0 DC 5.0
V_VCC VCC 0 DC 5.0

.control
tran 100u 10m
set filetype=ascii
write fan_controller_raw.raw all
.endc

.end
