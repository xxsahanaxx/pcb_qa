.title KiCad schematic

R1 NET0011 Net-_Q1-B_ 1k
R5 VCC Net-_Q1-C_ 10k
R4 +5V NET0012 10k
R3 VCC NET0003 10k
C2 VCC 0 100n
C3 +5V 0 100n
R7 /NET0004 NET0011 1k
R9 NET0003 /NET0006 1k

V_5V +5V 0 DC 5.0
V_VCC VCC 0 DC 5.0

.control
tran 100u 10m
set filetype=ascii
write fan_controller_raw.raw all
.endc

.end
