.title KiCad schematic

R9 NET0008 Net-_Q3-B_ 1k
R4 VCC Net-_Q2-G_ 10k
R8 +5V NET0012 10k
R2 VCC NET0007 10k
C2 VCC 0 100n
C3 +5V 0 100n
R7 /NET0011 NET0008 1k
R5 NET0007 /NET0003 1k

V_5V +5V 0 DC 5.0
V_VCC VCC 0 DC 5.0

.control
tran 100u 10m
set filetype=ascii
write fan_controller_raw.raw all
.endc

.end
