.title KiCad schematic

R1 NET0001 Net-_Q1-B_ 1k
R6 VCC Net-_Q1-C_ 10k
R8 +5V NET0011 10k
R5 VCC NET0007 10k
C2 VCC 0 100n
C3 +5V 0 100n
R4 /NET0006 NET0001 1k
R7 NET0007 /NET0003 1k

V_5V +5V 0 DC 5.0
V_VCC VCC 0 DC 5.0

.control
tran 100u 10m
set filetype=ascii
write fan_controller_raw.raw all
.endc

.end
