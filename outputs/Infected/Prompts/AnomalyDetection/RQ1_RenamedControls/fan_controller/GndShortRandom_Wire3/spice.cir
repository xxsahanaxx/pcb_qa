.title KiCad schematic

R6 NET0001 Net-_Q3-B_ 1k
R3 VCC Net-_Q2-G_ 10k
R2 +5V NET0006 10k
R5 VCC NET0004 10k
C2 VCC 0 100n
C3 +5V 0 100n
R4 /NET0003 NET0001 1k
R7 NET0004 /NET0007 1k

V_5V +5V 0 DC 5.0
V_VCC VCC 0 DC 5.0

.control
tran 100u 10m
set filetype=ascii
write fan_controller_raw.raw all
.endc

.end
