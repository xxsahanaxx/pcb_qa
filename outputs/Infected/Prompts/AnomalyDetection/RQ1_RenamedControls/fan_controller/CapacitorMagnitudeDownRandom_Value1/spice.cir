.title KiCad schematic

R1 NET0004 Net-_Q3-B_ 1k
R4 VCC Net-_Q2-G_ 10k
R5 +5V NET0012 10k
R9 VCC NET0010 10k
C3 VCC 0 100n
C1 +5V 0 100n
R2 /NET0008 NET0004 1k
R6 NET0010 /NET0007 1k

V_5V +5V 0 DC 5.0
V_VCC VCC 0 DC 5.0

.control
tran 100u 10m
set filetype=ascii
write fan_controller_raw.raw all
.endc

.end
