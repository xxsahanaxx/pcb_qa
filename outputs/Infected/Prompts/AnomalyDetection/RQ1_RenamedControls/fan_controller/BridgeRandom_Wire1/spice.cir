.title KiCad schematic

R3 NET0002 Net-_Q1-B_ 1k
R7 VCC Net-_Q1-C_ 10k
R6 +5V NET0005 10k
R2 VCC NET0008 10k
C3 VCC 0 100n
C1 +5V 0 100n
R9 /NET0009 NET0002 1k
R1 NET0008 /NET0010 1k

V_5V +5V 0 DC 5.0
V_VCC VCC 0 DC 5.0

.control
tran 100u 10m
set filetype=ascii
write fan_controller_raw.raw all
.endc

.end
