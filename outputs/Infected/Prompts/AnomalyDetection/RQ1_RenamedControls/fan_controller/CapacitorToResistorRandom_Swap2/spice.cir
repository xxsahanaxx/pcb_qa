.title KiCad schematic

R1 NET0008 Net-_Q1-B_ 1k
R4 VCC Net-_Q1-C_ 10k
R6 +5V NET0002 10k
R3 VCC NET0006 10k
C2 VCC 0 100n
C3 +5V 0 100n
R8 /NET0011 NET0008 1k
R9 NET0006 /NET0003 1k

V_5V +5V 0 DC 5.0
V_VCC VCC 0 DC 5.0

.control
tran 100u 10m
set filetype=ascii
write fan_controller_raw.raw all
.endc

.end
