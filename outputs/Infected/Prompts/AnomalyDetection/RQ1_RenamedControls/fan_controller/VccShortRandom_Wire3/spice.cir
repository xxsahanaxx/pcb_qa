.title KiCad schematic

R5 NET0007 Net-_Q1-B_ 1k
R8 VCC Net-_Q1-C_ 10k
R4 +5V NET0001 10k
R7 VCC NET0003 10k
C3 VCC 0 100n
C1 +5V 0 100n
R2 /NET0009 NET0007 1k
R9 NET0003 /NET0005 1k

V_5V +5V 0 DC 5.0
V_VCC VCC 0 DC 5.0

.control
tran 100u 10m
set filetype=ascii
write fan_controller_raw.raw all
.endc

.end
