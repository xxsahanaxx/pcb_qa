.title KiCad schematic

R7 NET0004 Net-_Q1-B_ 1k
R5 VCC Net-_Q1-C_ 10k
R6 +5V NET0011 10k
R9 VCC NET0005 10k
C2 VCC 0 100n
C1 +5V 0 100n
R1 /NET0002 NET0004 1k
R8 NET0005 /NET0008 1k

V_5V +5V 0 DC 5.0
V_VCC VCC 0 DC 5.0

.control
tran 100u 10m
set filetype=ascii
write fan_controller_raw.raw all
.endc

.end
