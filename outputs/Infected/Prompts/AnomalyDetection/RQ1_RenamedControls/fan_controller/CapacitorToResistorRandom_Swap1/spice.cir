.title KiCad schematic

R3 NET0011 Net-_Q3-B_ 1k
R2 VCC Net-_Q2-G_ 10k
R1 +5V NET0005 10k
R7 VCC NET0009 10k
C2 VCC 0 100n
C3 +5V 0 100n
R8 /NET0001 NET0011 1k
R5 NET0009 /NET0006 1k

V_5V +5V 0 DC 5.0
V_VCC VCC 0 DC 5.0

.control
tran 100u 10m
set filetype=ascii
write fan_controller_raw.raw all
.endc

.end
