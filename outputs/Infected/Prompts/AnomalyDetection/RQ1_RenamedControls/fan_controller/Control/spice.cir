.title KiCad schematic

R3 NET0001 Net-_Q1-B_ 1k
R2 VCC Net-_Q1-C_ 10k
R6 +5V NET0004 10k
R5 VCC NET0009 10k
C2 VCC 0 100n
C3 +5V 0 100n
R1 /NET0006 NET0001 1k
R8 NET0009 /NET0008 1k

V_5V +5V 0 DC 5.0
V_VCC VCC 0 DC 5.0

.control
tran 100u 10m
set filetype=ascii
write fan_controller_raw.raw all
.endc

.end
