.title KiCad schematic

R1 NET0005 Net-_Q1-B_ 1k
R7 VCC Net-_Q1-C_ 10k
R8 +5V NET0003 10k
R2 VCC NET0009 10k
C3 VCC 0 100n
C1 +5V 0 100n
R3 /NET0004 NET0005 1k
R9 NET0009 /NET0011 1k

V_5V +5V 0 DC 5.0
V_VCC VCC 0 DC 5.0

.control
tran 100u 10m
set filetype=ascii
write fan_controller_raw.raw all
.endc

.end
