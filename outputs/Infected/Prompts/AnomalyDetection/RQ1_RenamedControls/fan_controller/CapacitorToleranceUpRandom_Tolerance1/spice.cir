.title KiCad schematic

R6 NET0006 Net-_Q1-B_ 1k
R7 VCC Net-_Q1-C_ 10k
R8 +5V NET0005 10k
R9 VCC NET0010 10k
C2 VCC 0 100n
C3 +5V 0 100n
R3 /NET0012 NET0006 1k
R5 NET0010 /NET0001 1k

V_5V +5V 0 DC 5.0
V_VCC VCC 0 DC 5.0

.control
tran 100u 10m
set filetype=ascii
write fan_controller_raw.raw all
.endc

.end
