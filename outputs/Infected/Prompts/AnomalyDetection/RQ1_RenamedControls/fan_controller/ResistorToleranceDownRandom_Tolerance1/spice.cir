.title KiCad schematic

R4 NET0010 Net-_Q3-B_ 1k
R2 VCC Net-_Q2-G_ 10k
R7 +5V NET0006 10k
R9 VCC NET0008 10k
C2 VCC 0 100n
C3 +5V 0 100n
R1 /NET0002 NET0010 1k
R3 NET0008 /NET0004 1k

V_5V +5V 0 DC 5.0
V_VCC VCC 0 DC 5.0

.control
tran 100u 10m
set filetype=ascii
write fan_controller_raw.raw all
.endc

.end
