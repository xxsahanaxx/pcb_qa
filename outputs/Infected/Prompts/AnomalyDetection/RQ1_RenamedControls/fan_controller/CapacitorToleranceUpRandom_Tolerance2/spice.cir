.title KiCad schematic

R6 NET0001 Net-_Q3-B_ 1k
R4 VCC Net-_Q2-G_ 10k
R2 +5V NET0004 10k
R5 VCC NET0005 10k
C3 VCC 0 100n
C1 +5V 0 100n
R9 /NET0010 NET0001 1k
R7 NET0005 /NET0011 1k

V_5V +5V 0 DC 5.0
V_VCC VCC 0 DC 5.0

.control
tran 100u 10m
set filetype=ascii
write fan_controller_raw.raw all
.endc

.end
