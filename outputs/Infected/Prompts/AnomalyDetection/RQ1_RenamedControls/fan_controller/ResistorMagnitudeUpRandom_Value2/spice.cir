.title KiCad schematic

R1 NET0005 Net-_Q3-B_ 1k
R4 VCC Net-_Q2-G_ 10k
R2 +5V NET0009 10k
R5 VCC NET0010 10k
C3 VCC 0 100n
C1 +5V 0 100n
R8 /NET0006 NET0005 1k
R9 NET0010 /NET0002 1k

V_5V +5V 0 DC 5.0
V_VCC VCC 0 DC 5.0

.control
tran 100u 10m
set filetype=ascii
write fan_controller_raw.raw all
.endc

.end
