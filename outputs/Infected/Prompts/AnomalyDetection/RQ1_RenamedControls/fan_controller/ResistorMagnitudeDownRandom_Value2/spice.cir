.title KiCad schematic

R1 NET0006 Net-_Q3-B_ 1k
R5 VCC Net-_Q2-G_ 10k
R2 +5V NET0011 10k
R3 VCC NET0010 10k
C2 VCC 0 100n
C3 +5V 0 100n
R4 /NET0012 NET0006 1k
R7 NET0010 /NET0005 1k

V_5V +5V 0 DC 5.0
V_VCC VCC 0 DC 5.0

.control
tran 100u 10m
set filetype=ascii
write fan_controller_raw.raw all
.endc

.end
