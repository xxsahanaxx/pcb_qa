.title KiCad schematic

.model __D8 D

C42 0 Net-_U17-XTAL1_ 22pF
R5 Net-_U17-_RESET_ NET0004 10k
C86 0 NET0004 0.1uF
C52 0 NET0004 0.1uF
C66 Net-_U17-XTAL2_ 0 22pF
C20 0 Net-_U51-XTAL1_ 22pF
C16 Net-_U51-XTAL2_ 0 22pF
R29 Net-_U51-_RESET_ NET0004 10k
R48 NET0139 NET0004 1k
R83 NET0019 NET0004 1k
R32 /NET0096 NET0061 10k
C85 +3V3 0 0.1uF
R65 0 Net-_U22-SDO/SA1_ 5.1k
C17 Net-_U22-C1_ 0 0.1uF
C32 +3V3 0 1uF
C67 +3V3 0 0.1uF
C53 +5V 0 4.7uF
C3 +5V 0 1000uF
R62 NET0061 NET0041 2.2k
R12 +3V3 NET0062 10k
R10 NET0041 0 2.2k
R38 Net-_D37-K_ Net-_D9-A_ 51k
C18 VOUTP 0 47uF
D8 VOUTP Net-_D8-K_ __D8
R17 VOUTN Net-_D37-K_ 249k
R47 Net-_D39-K_ NET0176 470
R50 VOUTN VOUTP 24k
R71 +3V3 Net-_D14-A_ 56
C29 VOUTP VOUTN 0.1uF
R80 0 /NET0178 10k
R85 Net-_D48-K_ Net-_U46-Y_ 1k
R90 +3V3 Net-_D30-A_ 27
C27 5V_switched 0 0.1uF
R43 NET0025 Net-_D23-K_ 1k
R11 0 Net-_D21-K_ 200
C11 5V_switched 0 1uF
C12 +12V 0 1uF
C65 +3V3 0 10uF
C44 +5V 0 10uF
C34 +12V NET0104 22pF
R37 NET0104 +12V 1.8Meg
L1 +5V Net-_D43-A_ 10u
R42 0 NET0104 205k
C69 0 +3V3 0.1uF
C62 0 +3V3 0.1uF
R27 Net-_D2-K_ NET0050 470
R61 Net-_C48-Pad2_ Net-_C6-Pad1_ 75R
R87 Net-_C37-Pad2_ Net-_C6-Pad1_ 75R
C37 NET0162 Net-_C37-Pad2_ 22nF
C50 0 Net-_C50-Pad2_ 0.1uF
R53 Net-_C19-Pad2_ Net-_C6-Pad1_ 75R
R88 Net-_C30-Pad2_ Net-_C6-Pad1_ 75R
C6 Net-_C6-Pad1_ 0 1nF
C19 NET0183 Net-_C19-Pad2_ 22nF
C30 NET0129 Net-_C30-Pad2_ 22nF
C48 NET0068 Net-_C48-Pad2_ 22nF
C39 Net-_U31-OSC1_ 0 18pF
C46 Net-_U31-OSC2_ 0 18pF
C74 Net-_U55-OSC2_ 0 18pF
C4 0 NET0004 0.1uF
C77 NET0004 0 0.1uF
C68 0 5V_switched_CAN 0.1uF
R13 /NET0190 Net-_R13-Pad2_ 120
C80 0 5V_switched_CAN 0.1uF
R101 /NET0054 Net-_R101-Pad2_ 120
C23 0 NET0004 0.1uF
R70 Net-_U31-_RESET_ NET0004 10k
C33 Net-_U55-OSC1_ 0 18pF
R95 Net-_U55-_RESET_ NET0004 10k
C28 NET0004 0 0.1uF
C47 VMOT 0 47uF
C21 VMOT 0 4.7uF
R8 VMOT /NET0079 100k
C15 VMOT 0 0.1uF
R81 Net-_J16-CC2_ 0 5.1k
R79 0 Net-_J16-CC1_ 5.1k
C76 +5V 0 47uF
C41 VMOT 0 47uF
L2 Net-_D22-K_ +5V 100u
C7 +5V 0 47uF
R58 +5V Net-_Q5-G_ 10k
R75 5V_CAN_ENABLE Net-_JP12-A_ 10k
R98 +3V3 Net-_U38-A_ 10k
R69 +5V Net-_Q10-D_ 10k
R52 Net-_D46-K_ Net-_U40-A_ 130
R66 NET0146 +3V3 2.2k
R30 +3V3 Net-_U40-A_ 10k
R9 NET0014 +3V3 2.2k
C2 +3V3 0 0.1uF
C14 +3V3 0 470uF
R36 0 Net-_JP19-B_ 5.1k
C40 3.3V_PI_OUT 0 0.1uF
R82 3.3V_PI_OUT NET0007 10k
R100 3.3V_PI_OUT NET0008 10k
R21 NET0085 /NET0107 27
R33 +3V3 NET0075 10k
C61 +3V3 0 0.1uF
R56 NET0091 /NET0049 27
R63 +3V3 NET0168 10k
R76 +3V3 NET0021 10k
R64 NET0051 Net-_Q16-G_ 100
R45 NET0161 Net-_Q7-G_ 100
R19 NET0185 Net-_Q2-G_ 100
R59 NET0211 Net-_Q1-G_ 100
C43 +5V 0 0.1uF
C8 /NET0082 0 0.1uF
C79 +5V 0 10uF
C81 +5V 0 10uF
R6 VMOT Net-_R40-Pad1_ 50k
R28 Net-_D44-K_ Net-_U38-A_ 130
R94 NET0100 +3V3 2.2k
R89 Net-_D10-K1_ 0 130
R22 Net-_D10-K2_ NET0058 130
R51 /NET0177 +3V3 2.2k
C24 +3V3 0 0.1uF
R93 /NET0067 0 5.1k
R40 Net-_R40-Pad1_ /NET0067 50k
C56 0 +3V3 1uF
R55 +3V3 /NET0070 10k
R41 Net-_D16-K_ /NET0177 130
R54 +3V3 /NET0177 10k

V_12V +12V 0 DC 12.0
V_3V3 +3V3 0 DC 3.3
V_5V +5V 0 DC 5.0

.control
tran 100u 10m
set filetype=ascii
write cm4-robot_raw.raw all
.endc

.end
