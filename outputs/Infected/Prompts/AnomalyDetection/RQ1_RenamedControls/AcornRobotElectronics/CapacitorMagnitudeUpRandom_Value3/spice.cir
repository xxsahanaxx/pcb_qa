.title KiCad schematic

.model __D3 D

C82 0 Net-_U12-XTAL1_ 22pF
R77 Net-_U12-_RESET_ NET0117 10k
C56 0 NET0117 0.1uF
C8 0 NET0117 0.1uF
C25 Net-_U12-XTAL2_ 0 22pF
C75 0 Net-_U55-XTAL1_ 22pF
C46 Net-_U55-XTAL2_ 0 22pF
R84 Net-_U55-_RESET_ NET0117 10k
R45 NET0036 NET0117 1k
R66 NET0141 NET0117 1k
R85 /NET0115 NET0208 10k
C57 +3V3 0 0.1uF
R46 0 Net-_U18-SDO/SA1_ 5.1k
C14 Net-_U18-C1_ 0 0.1uF
C54 +3V3 0 1uF
C74 +3V3 0 0.1uF
C60 +5V 0 4.7uF
C11 +5V 0 1000uF
R72 NET0208 NET0112 2.2k
R76 +3V3 NET0021 10k
R59 NET0112 0 2.2k
R42 Net-_D49-K_ Net-_D11-A_ 51k
C48 VOUTP 0 47uF
D3 VOUTP Net-_D3-K_ __D3
R69 VOUTN Net-_D49-K_ 249k
R22 Net-_D38-K_ NET0097 470
R68 VOUTN VOUTP 24k
R62 +3V3 Net-_D39-A_ 56
C49 VOUTP VOUTN 0.1uF
R33 0 /NET0089 10k
R4 Net-_D14-K_ Net-_U10-Y_ 1k
R10 +3V3 Net-_D21-A_ 27
C84 5V_switched 0 0.1uF
R86 NET0040 Net-_D30-K_ 1k
R5 0 Net-_D37-K_ 200
C17 5V_switched 0 1uF
C35 +12V 0 1uF
C33 +3V3 0 10uF
C20 +5V 0 10uF
C43 +12V NET0119 22pF
R89 NET0119 +12V 1.8Meg
L1 +5V Net-_D13-A_ 10u
R55 0 NET0119 205k
C13 0 +3V3 0.1uF
C59 0 +3V3 0.1uF
R53 Net-_D20-K_ NET0114 470
R97 Net-_C1-Pad2_ Net-_C2-Pad1_ 75R
R75 Net-_C4-Pad2_ Net-_C2-Pad1_ 75R
C4 NET0137 Net-_C4-Pad2_ 22nF
C65 0 Net-_C65-Pad2_ 0.1uF
R61 Net-_C6-Pad2_ Net-_C2-Pad1_ 75R
R94 Net-_C10-Pad2_ Net-_C2-Pad1_ 75R
C2 Net-_C2-Pad1_ 0 1nF
C6 NET0144 Net-_C6-Pad2_ 22nF
C10 NET0203 Net-_C10-Pad2_ 22nF
C1 NET0059 Net-_C1-Pad2_ 22nF
C70 Net-_U22-OSC1_ 0 18pF
C66 Net-_U22-OSC2_ 0 18pF
C27 Net-_U32-OSC2_ 0 18pF
C26 0 NET0117 0.1uF
C69 NET0117 0 0.1uF
C23 0 5V_switched_CAN 0.1uF
R67 /NET0038 Net-_R67-Pad2_ 120
C42 0 5V_switched_CAN 0.1uF
R80 /NET0169 Net-_R80-Pad2_ 120
C63 0 NET0117 0.1uF
R14 Net-_U22-_RESET_ NET0117 10k
C37 Net-_U32-OSC1_ 0 18pF
R43 Net-_U32-_RESET_ NET0117 10k
C83 NET0117 0 0.1uF
C76 VMOT 0 47uF
C85 VMOT 0 4.7uF
R30 VMOT /NET0176 100k
C24 VMOT 0 0.1uF
R54 Net-_J26-CC2_ 0 5.1k
R73 0 Net-_J26-CC1_ 5.1k
C79 +5V 0 47uF
C5 VMOT 0 47uF
L3 Net-_D5-K_ +5V 100u
C80 +5V 0 47uF
R1 +5V Net-_Q11-G_ 10k
R99 5V_CAN_ENABLE Net-_JP12-A_ 10k
R3 +3V3 Net-_U27-A_ 10k
R29 +5V Net-_Q13-D_ 10k
R101 Net-_D2-K_ Net-_U31-A_ 130
R40 NET0063 +3V3 2.2k
R81 +3V3 Net-_U31-A_ 10k
R88 NET0206 +3V3 2.2k
C19 +3V3 0 0.1uF
C38 +3V3 0 470uF
R31 0 Net-_JP23-B_ 5.1k
C78 3.3V_PI_OUT 0 0.1uF
R26 3.3V_PI_OUT NET0155 10k
R35 3.3V_PI_OUT NET0062 10k
R96 NET0213 /NET0037 27
R56 +3V3 NET0028 10k
C3 +3V3 0 0.1uF
R13 NET0166 /NET0095 27
R16 +3V3 NET0101 10k
R50 +3V3 NET0052 10k
R47 NET0065 Net-_Q7-G_ 100
R92 NET0022 Net-_Q4-G_ 100
R91 NET0100 Net-_Q8-G_ 100
R51 NET0070 Net-_Q5-G_ 100
C9 +5V 0 0.1uF
C64 /NET0057 0 0.1uF
C21 +5V 0 10uF
C58 +5V 0 10uF
R25 VMOT Net-_R25-Pad2_ 50k
R39 Net-_D32-K_ Net-_U27-A_ 130
R90 NET0107 +3V3 2.2k
R20 Net-_D46-K1_ 0 130
R17 Net-_D46-K2_ NET0044 130
R18 /NET0049 +3V3 2.2k
C72 +3V3 0 0.1uF
R34 /NET0124 0 5.1k
R70 Net-_R25-Pad2_ /NET0124 50k
C16 0 +3V3 1uF
R32 +3V3 /NET0084 10k
R74 Net-_D26-K_ /NET0049 130
R6 +3V3 /NET0049 10k

V_12V +12V 0 DC 12.0
V_3V3 +3V3 0 DC 3.3
V_5V +5V 0 DC 5.0

.control
tran 100u 10m
set filetype=ascii
write cm4-robot_raw.raw all
.endc

.end
