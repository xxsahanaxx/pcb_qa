.title KiCad schematic

.model __D36 D

C30 0 Net-_U34-XTAL1_ 22pF
R39 Net-_U34-_RESET_ NET0126 10k
C39 0 NET0126 0.1uF
C41 0 NET0126 0.1uF
C35 Net-_U34-XTAL2_ 0 22pF
C50 0 Net-_U35-XTAL1_ 22pF
C34 Net-_U35-XTAL2_ 0 22pF
R79 Net-_U35-_RESET_ NET0126 10k
R68 NET0159 NET0126 1k
R87 NET0065 NET0126 1k
R57 /NET0017 NET0100 10k
C73 +3V3 0 0.1uF
R32 0 Net-_U48-SDO/SA1_ 5.1k
C4 Net-_U48-C1_ 0 0.1uF
C11 +3V3 0 0.1uF
C7 +3V3 0 1uF
C49 +5V 0 4.7uF
C6 +5V 0 1000uF
R88 NET0100 NET0150 2.2k
R62 +3V3 NET0120 10k
R84 NET0150 0 2.2k
R92 Net-_D4-K_ Net-_D40-A_ 51k
C33 VOUTP 0 47uF
D36 VOUTP Net-_D36-K_ __D36
R78 VOUTN Net-_D4-K_ 249k
R60 Net-_D3-K_ NET0185 470
R75 VOUTN VOUTP 24k
R53 +3V3 Net-_D30-A_ 56
C76 VOUTP VOUTN 0.1uF
R49 0 /NET0053 10k
R37 Net-_D15-K_ Net-_U11-Y_ 1k
R97 +3V3 Net-_D35-A_ 27
C78 5V_switched 0 0.1uF
R31 NET0050 Net-_D12-K_ 1k
R7 0 Net-_D11-K_ 200
C43 5V_switched 0 1uF
C53 +12V 0 1uF
C26 +3V3 0 10uF
C40 +5V 0 10uF
C1 +12V NET0097 22pF
R36 NET0097 +12V 1.8Meg
L3 +5V Net-_D38-A_ 10u
R71 0 NET0097 205k
C36 0 +3V3 0.1uF
C57 0 +3V3 0.1uF
R9 Net-_D45-K_ NET0135 470
R15 Net-_C56-Pad2_ Net-_C58-Pad1_ 75R
R67 Net-_C21-Pad2_ Net-_C58-Pad1_ 75R
C21 NET0172 Net-_C21-Pad2_ 22nF
C25 0 Net-_C25-Pad2_ 0.1uF
R81 Net-_C72-Pad2_ Net-_C58-Pad1_ 75R
R94 Net-_C70-Pad2_ Net-_C58-Pad1_ 75R
C58 Net-_C58-Pad1_ 0 1nF
C72 NET0134 Net-_C72-Pad2_ 22nF
C70 NET0121 Net-_C70-Pad2_ 22nF
C56 NET0047 Net-_C56-Pad2_ 22nF
C48 Net-_U38-OSC1_ 0 18pF
C63 Net-_U38-OSC2_ 0 18pF
C79 Net-_U3-OSC2_ 0 18pF
C12 0 NET0126 0.1uF
C64 NET0126 0 0.1uF
C61 0 5V_switched_CAN 0.1uF
R20 /NET0060 Net-_R20-Pad2_ 120
C45 0 5V_switched_CAN 0.1uF
R48 /NET0028 Net-_R48-Pad2_ 120
C22 0 NET0126 0.1uF
R40 Net-_U38-_RESET_ NET0126 10k
C86 Net-_U3-OSC1_ 0 18pF
R12 Net-_U3-_RESET_ NET0126 10k
C28 NET0126 0 0.1uF
C46 VMOT 0 47uF
C23 VMOT 0 4.7uF
R16 VMOT /NET0031 100k
C44 VMOT 0 0.1uF
R66 Net-_J5-CC2_ 0 5.1k
R30 0 Net-_J5-CC1_ 5.1k
C27 +5V 0 47uF
C17 VMOT 0 47uF
L2 Net-_D17-K_ +5V 100u
C71 +5V 0 47uF
R85 +5V Net-_Q5-G_ 10k
R55 5V_CAN_ENABLE Net-_JP17-A_ 10k
R47 +3V3 Net-_U17-Y_ 10k
R89 +5V Net-_Q12-D_ 10k
R13 Net-_D46-K_ Net-_U17-A_ 130
R63 NET0152 +3V3 2.2k
R29 +3V3 Net-_U17-A_ 10k
R26 NET0182 +3V3 2.2k
C13 +3V3 0 0.1uF
C66 +3V3 0 470uF
R98 0 Net-_JP16-B_ 5.1k
R93 NET0101 /NET0111 27
R45 +3V3 NET0131 10k
C15 +3V3 0 0.1uF
R102 NET0066 /NET0083 27
R73 +3V3 NET0096 10k
R17 NET0055 Net-_Q1-G_ 100
R82 NET0197 Net-_Q14-G_ 100
R58 NET0202 Net-_Q11-G_ 100
R51 NET0139 Net-_Q16-G_ 100
R22 +3V3 NET0198 10k
C67 3.3V_PI_OUT 0 0.1uF
R2 3.3V_PI_OUT NET0180 10k
R25 3.3V_PI_OUT NET0020 10k
C74 +5V 0 0.1uF
C42 /NET0214 0 0.1uF
C9 +5V 0 10uF
C55 +5V 0 10uF
R95 VMOT Net-_R42-Pad1_ 50k
R59 Net-_D33-K_ Net-_U17-Y_ 130
R34 NET0207 +3V3 2.2k
R6 Net-_D9-K1_ 0 130
R27 Net-_D9-K2_ NET0046 130
R54 /NET0098 +3V3 2.2k
C32 +3V3 0 0.1uF
R14 /NET0057 0 5.1k
R42 Net-_R42-Pad1_ /NET0057 50k
C54 0 +3V3 1uF
R99 +3V3 /NET0119 10k
R1 Net-_D22-K_ /NET0098 130
R80 +3V3 /NET0098 10k

V_12V +12V 0 DC 12.0
V_3V3 +3V3 0 DC 3.3
V_5V +5V 0 DC 5.0

.control
tran 100u 10m
set filetype=ascii
write cm4-robot_raw.raw all
.endc

.end
