.title KiCad schematic

.model __D15 D

C76 0 Net-_U35-XTAL1_ 22pF
R73 Net-_U35-_RESET_ NET0172 10k
C65 0 NET0172 0.1uF
C46 0 NET0172 0.1uF
C19 Net-_U35-XTAL2_ 0 22pF
C10 0 Net-_U6-XTAL1_ 22pF
C15 Net-_U6-XTAL2_ 0 22pF
R56 Net-_U6-_RESET_ NET0172 10k
R27 NET0086 NET0172 1k
R13 NET0142 NET0172 1k
R58 /NET0075 NET0082 10k
C59 +3V3 0 0.1uF
R75 0 Net-_U49-SDO/SA1_ 5.1k
C73 Net-_U49-C1_ 0 0.1uF
C3 +3V3 0 1uF
C8 +3V3 0 0.1uF
C21 +5V 0 4.7uF
C78 +5V 0 1000uF
R32 NET0082 NET0197 2.2k
R49 +3V3 NET0166 10k
R2 NET0197 0 2.2k
R33 Net-_D3-K_ Net-_D14-A_ 51k
C66 VOUTP 0 47uF
D15 VOUTP Net-_D15-K_ __D15
R1 VOUTN Net-_D3-K_ 249k
R72 Net-_D20-K_ NET0154 470
R57 VOUTN VOUTP 24k
R83 +3V3 Net-_D33-A_ 56
C7 VOUTP VOUTN 0.1uF
R93 0 /NET0038 10k
R60 Net-_D36-K_ Net-_U14-Y_ 1k
R63 +3V3 Net-_D47-A_ 27
C58 5V_switched 0 0.1uF
R26 NET0131 Net-_D41-K_ 1k
R89 0 Net-_D22-K_ 200
C9 5V_switched 0 1uF
C37 +12V 0 1uF
C4 +3V3 0 10uF
C5 +5V 0 10uF
C77 +12V NET0113 22pF
R76 NET0113 +12V 1.8Meg
L1 +5V Net-_D35-A_ 10u
R35 0 NET0113 205k
C28 0 +3V3 0.1uF
C86 0 +3V3 0.1uF
R24 Net-_D25-K_ NET0165 470
R8 Net-_C13-Pad2_ Net-_C52-Pad1_ 75R
R85 Net-_C47-Pad2_ Net-_C52-Pad1_ 75R
C47 NET0168 Net-_C47-Pad2_ 22nF
C6 0 Net-_C6-Pad2_ 0.1uF
R14 Net-_C68-Pad2_ Net-_C52-Pad1_ 75R
R9 Net-_C71-Pad2_ Net-_C52-Pad1_ 75R
C52 Net-_C52-Pad1_ 0 1nF
C68 NET0064 Net-_C68-Pad2_ 22nF
C71 NET0117 Net-_C71-Pad2_ 22nF
C13 NET0184 Net-_C13-Pad2_ 22nF
C69 Net-_U7-OSC1_ 0 18pF
C70 Net-_U7-OSC2_ 0 18pF
C23 Net-_U5-OSC2_ 0 18pF
C55 0 NET0172 0.1uF
C63 NET0172 0 0.1uF
C22 0 5V_switched_CAN 0.1uF
R31 /NET0209 Net-_R31-Pad2_ 120
C61 0 5V_switched_CAN 0.1uF
R15 /NET0069 Net-_R15-Pad2_ 120
C26 0 NET0172 0.1uF
R34 Net-_U7-_RESET_ NET0172 10k
C45 Net-_U5-OSC1_ 0 18pF
R40 Net-_U5-_RESET_ NET0172 10k
C48 NET0172 0 0.1uF
C35 VMOT 0 47uF
C85 VMOT 0 4.7uF
R42 VMOT /NET0177 100k
C20 VMOT 0 0.1uF
R22 Net-_J19-CC2_ 0 5.1k
R51 0 Net-_J19-CC1_ 5.1k
C30 +5V 0 47uF
C14 VMOT 0 47uF
L3 Net-_D11-K_ +5V 100u
C38 +5V 0 47uF
R97 +5V Net-_Q16-G_ 10k
R64 5V_CAN_ENABLE Net-_JP19-A_ 10k
R38 +3V3 Net-_U15-A_ 10k
R92 +5V Net-_Q1-G_ 10k
R100 Net-_D7-K_ Net-_U40-A_ 130
R84 NET0107 +3V3 2.2k
R55 +3V3 Net-_U40-A_ 10k
R23 NET0022 +3V3 2.2k
C39 +3V3 0 0.1uF
C80 +3V3 0 470uF
R71 0 Net-_JP8-B_ 5.1k
C67 3.3V_PI_OUT 0 0.1uF
R7 3.3V_PI_OUT NET0144 10k
R66 3.3V_PI_OUT NET0124 10k
R28 NET0116 /NET0035 27
R96 +3V3 NET0208 10k
C17 +3V3 0 0.1uF
R10 NET0123 /NET0185 27
R59 +3V3 NET0203 10k
R39 +3V3 NET0042 10k
R99 NET0094 Net-_Q13-G_ 100
R91 NET0210 Net-_Q15-G_ 100
R47 NET0023 Net-_Q9-G_ 100
R80 NET0111 Net-_Q10-G_ 100
C82 +5V 0 0.1uF
C81 /NET0084 0 0.1uF
C31 +5V 0 10uF
C40 +5V 0 10uF
R54 VMOT Net-_R41-Pad1_ 50k
R77 Net-_D44-K_ Net-_U15-A_ 130
R30 NET0057 +3V3 2.2k
R78 Net-_D12-K1_ 0 130
R65 Net-_D12-K2_ NET0139 130
R44 /NET0163 +3V3 2.2k
C24 +3V3 0 0.1uF
R25 /NET0052 0 5.1k
R41 Net-_R41-Pad1_ /NET0052 50k
C53 0 +3V3 1uF
R86 +3V3 /NET0081 10k
R82 Net-_D18-K_ /NET0163 130
R79 +3V3 /NET0163 10k

V_12V +12V 0 DC 12.0
V_3V3 +3V3 0 DC 3.3
V_5V +5V 0 DC 5.0

.control
tran 100u 10m
set filetype=ascii
write cm4-robot_raw.raw all
.endc

.end
