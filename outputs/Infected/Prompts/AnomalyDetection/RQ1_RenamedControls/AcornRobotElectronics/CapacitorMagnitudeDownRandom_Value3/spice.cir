.title KiCad schematic

.model __D39 D

C71 0 Net-_U28-XTAL1_ 22pF
R65 Net-_U28-_RESET_ NET0137 10k
C66 0 NET0137 0.1uF
C57 0 NET0137 0.1uF
C2 Net-_U28-XTAL2_ 0 22pF
C74 0 Net-_U27-XTAL1_ 22pF
C84 Net-_U27-XTAL2_ 0 22pF
R4 Net-_U27-_RESET_ NET0137 10k
R86 NET0005 NET0137 1k
R92 NET0099 NET0137 1k
R47 /NET0116 NET0111 10k
C4 +3V3 0 0.1uF
R35 0 Net-_U29-SDO/SA1_ 5.1k
C60 Net-_U29-C1_ 0 0.1uF
C27 +3V3 0 1uF
C54 +3V3 0 0.1uF
C81 +5V 0 4.7uF
C67 +5V 0 1000uF
R101 NET0111 NET0140 2.2k
R89 +3V3 NET0092 10k
R1 NET0140 0 2.2k
R15 Net-_D37-K_ Net-_D36-A_ 51k
C46 VOUTP 0 47uF
D39 VOUTP Net-_D39-K_ __D39
R95 VOUTN Net-_D37-K_ 249k
R33 Net-_D5-K_ NET0108 470
R8 VOUTN VOUTP 24k
R46 +3V3 Net-_D1-A_ 56
C80 VOUTP VOUTN 0.1uF
R18 0 /NET0102 10k
R58 Net-_D26-K_ Net-_U57-Y_ 1k
R98 +3V3 Net-_D32-A_ 27
C10 5V_switched 0 0.1uF
R22 NET0094 Net-_D22-K_ 1k
R76 0 Net-_D7-K_ 200
C19 5V_switched 0 1uF
C72 +12V 0 1uF
C12 +3V3 0 10uF
C16 +5V 0 10uF
C20 +12V NET0119 22pF
R91 NET0119 +12V 1.8Meg
L3 +5V Net-_D14-A_ 10u
R13 0 NET0119 205k
C30 0 +3V3 0.1uF
C32 0 +3V3 0.1uF
R68 Net-_D8-K_ NET0205 470
R72 Net-_C22-Pad2_ Net-_C24-Pad1_ 75R
R67 Net-_C65-Pad2_ Net-_C24-Pad1_ 75R
C65 NET0159 Net-_C65-Pad2_ 22nF
C14 0 Net-_C14-Pad2_ 0.1uF
R102 Net-_C23-Pad2_ Net-_C24-Pad1_ 75R
R83 Net-_C35-Pad2_ Net-_C24-Pad1_ 75R
C24 Net-_C24-Pad1_ 0 1nF
C23 NET0071 Net-_C23-Pad2_ 22nF
C35 NET0084 Net-_C35-Pad2_ 22nF
C22 NET0128 Net-_C22-Pad2_ 22nF
C55 Net-_U33-OSC1_ 0 18pF
C85 Net-_U33-OSC2_ 0 18pF
C44 Net-_U38-OSC2_ 0 18pF
C41 0 NET0137 0.1uF
C31 NET0137 0 0.1uF
C37 0 5V_switched_CAN 0.1uF
R75 /NET0183 Net-_R75-Pad2_ 120
C62 0 5V_switched_CAN 0.1uF
R29 /NET0170 Net-_R29-Pad2_ 120
C70 0 NET0137 0.1uF
R12 Net-_U33-_RESET_ NET0137 10k
C76 Net-_U38-OSC1_ 0 18pF
R54 Net-_U38-_RESET_ NET0137 10k
C69 NET0137 0 0.1uF
C43 VMOT 0 47uF
C73 VMOT 0 4.7uF
R23 VMOT /NET0007 100k
C5 VMOT 0 0.1uF
R81 Net-_J28-CC2_ 0 5.1k
R31 0 Net-_J28-CC1_ 5.1k
C21 +5V 0 47uF
C79 VMOT 0 47uF
L2 Net-_D40-K_ +5V 100u
C75 +5V 0 47uF
R52 +5V Net-_Q3-G_ 10k
R20 5V_CAN_ENABLE Net-_JP8-A_ 10k
R100 +3V3 Net-_U22-Y_ 10k
R21 +5V Net-_Q12-D_ 10k
R37 Net-_D38-K_ Net-_U22-A_ 130
R3 NET0157 +3V3 2.2k
R66 +3V3 Net-_U22-A_ 10k
R70 NET0199 +3V3 2.2k
C18 +3V3 0 0.1uF
C3 +3V3 0 470uF
R42 0 Net-_JP14-B_ 5.1k
R96 NET0156 /NET0149 27
R79 +3V3 NET0207 10k
C8 +3V3 0 0.1uF
R51 NET0002 /NET0113 27
R26 +3V3 NET0174 10k
R28 NET0164 Net-_Q4-G_ 100
R16 NET0095 Net-_Q8-G_ 100
R17 NET0143 Net-_Q13-G_ 100
R7 NET0047 Net-_Q2-G_ 100
R25 +3V3 NET0015 10k
C34 3.3V_PI_OUT 0 0.1uF
R5 3.3V_PI_OUT NET0037 10k
R32 3.3V_PI_OUT NET0201 10k
C6 +5V 0 0.1uF
C9 /NET0125 0 0.1uF
C47 +5V 0 10uF
C45 +5V 0 10uF
R43 VMOT Net-_R43-Pad2_ 50k
R56 Net-_D20-K_ Net-_U22-Y_ 130
R87 NET0044 +3V3 2.2k
R94 Net-_D27-K1_ 0 130
R73 Net-_D27-K2_ NET0070 130
R2 /NET0210 +3V3 2.2k
C58 +3V3 0 0.1uF
R50 /NET0030 0 5.1k
R59 Net-_R43-Pad2_ /NET0030 50k
C39 0 +3V3 1uF
R71 +3V3 /NET0057 10k
R45 Net-_D33-K_ /NET0210 130
R55 +3V3 /NET0210 10k

V_12V +12V 0 DC 12.0
V_3V3 +3V3 0 DC 3.3
V_5V +5V 0 DC 5.0

.control
tran 100u 10m
set filetype=ascii
write cm4-robot_raw.raw all
.endc

.end
