.title KiCad schematic

.model __D27 D

C40 0 Net-_U35-XTAL1_ 22pF
R50 Net-_U35-_RESET_ NET0166 10k
C83 0 NET0166 0.1uF
C81 0 NET0166 0.1uF
C48 Net-_U35-XTAL2_ 0 22pF
C9 0 Net-_U32-XTAL1_ 22pF
C38 Net-_U32-XTAL2_ 0 22pF
R38 Net-_U32-_RESET_ NET0166 10k
R33 NET0154 NET0166 1k
R13 NET0125 NET0166 1k
R27 /NET0114 NET0149 10k
C3 +3V3 0 0.1uF
R6 0 Net-_U19-SDO/SA1_ 5.1k
C25 Net-_U19-C1_ 0 0.1uF
C69 +3V3 0 1uF
C71 +3V3 0 0.1uF
C57 +5V 0 4.7uF
C37 +5V 0 1000uF
R44 NET0149 NET0159 2.2k
R63 +3V3 NET0029 10k
R59 NET0159 0 2.2k
R97 Net-_D16-K_ Net-_D48-A_ 51k
C61 VOUTP 0 47uF
D27 VOUTP Net-_D27-K_ __D27
R48 VOUTN Net-_D16-K_ 249k
R56 Net-_D3-K_ NET0182 470
R72 VOUTN VOUTP 24k
R11 +3V3 Net-_D5-A_ 56
C84 VOUTP VOUTN 0.1uF
R18 0 /NET0086 10k
R42 Net-_D24-K_ Net-_U27-Y_ 1k
R32 +3V3 Net-_D36-A_ 27
C17 5V_switched 0 0.1uF
R77 NET0148 Net-_D42-K_ 1k
R82 0 Net-_D4-K_ 200
C43 5V_switched 0 1uF
C55 +12V 0 1uF
C22 +3V3 0 10uF
C73 +5V 0 10uF
C5 +12V NET0023 22pF
R22 NET0023 +12V 1.8Meg
L1 +5V Net-_D9-A_ 10u
R9 0 NET0023 205k
C63 0 +3V3 0.1uF
C70 0 +3V3 0.1uF
R78 Net-_D1-K_ NET0174 470
R41 Net-_C64-Pad2_ Net-_C7-Pad1_ 75R
R84 Net-_C76-Pad2_ Net-_C7-Pad1_ 75R
C76 NET0074 Net-_C76-Pad2_ 22nF
C41 0 Net-_C41-Pad2_ 0.1uF
R89 Net-_C82-Pad2_ Net-_C7-Pad1_ 75R
R49 Net-_C49-Pad2_ Net-_C7-Pad1_ 75R
C7 Net-_C7-Pad1_ 0 1nF
C82 NET0164 Net-_C82-Pad2_ 22nF
C49 NET0128 Net-_C49-Pad2_ 22nF
C64 NET0152 Net-_C64-Pad2_ 22nF
C13 Net-_U1-OSC1_ 0 18pF
C46 Net-_U1-OSC2_ 0 18pF
C85 Net-_U22-OSC2_ 0 18pF
C62 0 NET0166 0.1uF
C86 NET0166 0 0.1uF
C31 0 5V_switched_CAN 0.1uF
R3 /NET0092 Net-_R3-Pad2_ 120
C29 0 5V_switched_CAN 0.1uF
R12 /NET0063 Net-_R12-Pad2_ 120
C4 0 NET0166 0.1uF
R95 Net-_U1-_RESET_ NET0166 10k
C47 Net-_U22-OSC1_ 0 18pF
R23 Net-_U22-_RESET_ NET0166 10k
C20 NET0166 0 0.1uF
C79 VMOT 0 47uF
C21 VMOT 0 4.7uF
R58 VMOT /NET0211 100k
C77 VMOT 0 0.1uF
R102 Net-_J4-CC2_ 0 5.1k
R45 0 Net-_J4-CC1_ 5.1k
C66 +5V 0 47uF
C36 VMOT 0 47uF
L3 Net-_D7-K_ +5V 100u
C44 +5V 0 47uF
R85 +5V Net-_Q16-G_ 10k
R83 5V_CAN_ENABLE Net-_JP6-A_ 10k
R37 +3V3 Net-_U34-Y_ 10k
R47 +5V Net-_Q12-D_ 10k
R79 Net-_D2-K_ Net-_U29-Y_ 130
R87 NET0027 +3V3 2.2k
R70 +3V3 Net-_U29-Y_ 10k
R24 NET0097 +3V3 2.2k
C26 +3V3 0 0.1uF
C53 +3V3 0 470uF
R90 0 Net-_JP18-B_ 5.1k
R21 NET0007 /NET0024 27
R101 +3V3 NET0171 10k
C52 +3V3 0 0.1uF
R93 NET0126 /NET0010 27
R62 +3V3 NET0011 10k
R26 NET0098 Net-_Q2-G_ 100
R57 NET0026 Net-_Q8-G_ 100
R64 NET0034 Net-_Q11-G_ 100
R31 NET0004 Net-_Q7-G_ 100
R68 +3V3 NET0044 10k
C12 3.3V_PI_OUT 0 0.1uF
R16 3.3V_PI_OUT NET0038 10k
R20 3.3V_PI_OUT NET0053 10k
C14 +5V 0 0.1uF
C80 /NET0135 0 0.1uF
C11 +5V 0 10uF
C68 +5V 0 10uF
R86 VMOT Net-_R14-Pad1_ 50k
R60 Net-_D38-K_ Net-_U34-Y_ 130
R1 NET0077 +3V3 2.2k
R74 Net-_D20-K1_ 0 130
R76 Net-_D20-K2_ NET0036 130
R51 /NET0189 +3V3 2.2k
C23 +3V3 0 0.1uF
R92 /NET0045 0 5.1k
R14 Net-_R14-Pad1_ /NET0045 50k
C6 0 +3V3 1uF
R67 +3V3 /NET0096 10k
R4 Net-_D11-K_ /NET0189 130
R91 +3V3 /NET0189 10k

V_12V +12V 0 DC 12.0
V_3V3 +3V3 0 DC 3.3
V_5V +5V 0 DC 5.0

.control
tran 100u 10m
set filetype=ascii
write cm4-robot_raw.raw all
.endc

.end
