.title KiCad schematic

.model __D13 D

C5 0 Net-_U29-XTAL1_ 22pF
R82 Net-_U29-_RESET_ NET0016 10k
C27 0 NET0016 0.1uF
C4 0 NET0016 0.1uF
C25 Net-_U29-XTAL2_ 0 22pF
C31 0 Net-_U48-XTAL1_ 22pF
C18 Net-_U48-XTAL2_ 0 22pF
R49 Net-_U48-_RESET_ NET0016 10k
R61 NET0053 NET0016 1k
R2 NET0189 NET0016 1k
R99 /NET0100 NET0002 10k
C63 +3V3 0 0.1uF
R5 0 Net-_U23-SDO/SA1_ 5.1k
C51 Net-_U23-C1_ 0 0.1uF
C71 +3V3 0 1uF
C13 +3V3 0 0.1uF
C37 +5V 0 4.7uF
C82 +5V 0 1000uF
R71 NET0002 NET0001 2.2k
R62 +3V3 NET0021 10k
R37 NET0001 0 2.2k
R93 Net-_D36-K_ Net-_D4-A_ 51k
C84 VOUTP 0 47uF
D13 VOUTP Net-_D13-K_ __D13
R51 VOUTN Net-_D36-K_ 249k
R26 Net-_D49-K_ NET0116 470
R40 VOUTN VOUTP 24k
R13 +3V3 Net-_D35-A_ 56
C65 VOUTP VOUTN 0.1uF
R96 0 /NET0074 10k
R57 Net-_D15-K_ Net-_U8-Y_ 1k
R91 +3V3 Net-_D26-A_ 27
C55 5V_switched 0 0.1uF
R98 NET0138 Net-_D17-K_ 1k
R3 0 Net-_D7-K_ 200
C41 5V_switched 0 1uF
C19 +12V 0 1uF
C75 +3V3 0 10uF
C78 +5V 0 10uF
C50 +12V NET0013 22pF
R24 NET0013 +12V 1.8Meg
L1 +5V Net-_D8-A_ 10u
R8 0 NET0013 205k
C79 0 +3V3 0.1uF
C68 0 +3V3 0.1uF
R43 Net-_D43-K_ NET0033 470
R50 Net-_C26-Pad2_ Net-_C6-Pad1_ 75R
R95 Net-_C40-Pad2_ Net-_C6-Pad1_ 75R
C40 NET0161 Net-_C40-Pad2_ 22nF
C80 0 Net-_C80-Pad2_ 0.1uF
R17 Net-_C34-Pad2_ Net-_C6-Pad1_ 75R
R65 Net-_C2-Pad2_ Net-_C6-Pad1_ 75R
C6 Net-_C6-Pad1_ 0 1nF
C34 NET0104 Net-_C34-Pad2_ 22nF
C2 NET0183 Net-_C2-Pad2_ 22nF
C26 NET0149 Net-_C26-Pad2_ 22nF
C21 Net-_U28-OSC1_ 0 18pF
C39 Net-_U28-OSC2_ 0 18pF
C70 Net-_U7-OSC2_ 0 18pF
C53 0 NET0016 0.1uF
C77 NET0016 0 0.1uF
C49 0 5V_switched_CAN 0.1uF
R35 /NET0122 Net-_R35-Pad2_ 120
C81 0 5V_switched_CAN 0.1uF
R80 /NET0020 Net-_R80-Pad2_ 120
C10 0 NET0016 0.1uF
R27 Net-_U28-_RESET_ NET0016 10k
C59 Net-_U7-OSC1_ 0 18pF
R89 Net-_U7-_RESET_ NET0016 10k
C44 NET0016 0 0.1uF
C36 VMOT 0 47uF
C17 VMOT 0 4.7uF
R68 VMOT /NET0023 100k
C54 VMOT 0 0.1uF
R30 Net-_J34-CC2_ 0 5.1k
R55 0 Net-_J34-CC1_ 5.1k
C12 +5V 0 47uF
C57 VMOT 0 47uF
L3 Net-_D40-K_ +5V 100u
C74 +5V 0 47uF
R66 +5V Net-_Q3-G_ 10k
R84 5V_CAN_ENABLE Net-_JP19-A_ 10k
R73 +3V3 Net-_U18-A_ 10k
R22 +5V Net-_Q10-G_ 10k
R53 Net-_D41-K_ Net-_U24-Y_ 130
R48 NET0125 +3V3 2.2k
R14 +3V3 Net-_U24-Y_ 10k
R63 NET0062 +3V3 2.2k
C23 +3V3 0 0.1uF
C7 +3V3 0 470uF
R85 0 Net-_JP8-B_ 5.1k
C20 3.3V_PI_OUT 0 0.1uF
R44 3.3V_PI_OUT NET0197 10k
R78 3.3V_PI_OUT NET0055 10k
R60 NET0146 /NET0187 27
R38 +3V3 NET0063 10k
C3 +3V3 0 0.1uF
R1 NET0112 /NET0034 27
R76 +3V3 NET0157 10k
R70 +3V3 NET0031 10k
R39 NET0124 Net-_Q2-G_ 100
R46 NET0195 Net-_Q11-G_ 100
R21 NET0067 Net-_Q7-G_ 100
R4 NET0110 Net-_Q8-G_ 100
C52 +5V 0 0.1uF
C15 /NET0035 0 0.1uF
C86 +5V 0 10uF
C29 +5V 0 10uF
R74 VMOT Net-_R56-Pad1_ 50k
R9 Net-_D38-K_ Net-_U18-A_ 130
R11 NET0194 +3V3 2.2k
R18 Net-_D46-K1_ 0 130
R54 Net-_D46-K2_ NET0012 130
R52 /NET0172 +3V3 2.2k
C9 +3V3 0 0.1uF
R72 /NET0088 0 5.1k
R56 Net-_R56-Pad1_ /NET0088 50k
C22 0 +3V3 1uF
R69 +3V3 /NET0106 10k
R23 Net-_D30-K_ /NET0172 130
R16 +3V3 /NET0172 10k

V_12V +12V 0 DC 12.0
V_3V3 +3V3 0 DC 3.3
V_5V +5V 0 DC 5.0

.control
tran 100u 10m
set filetype=ascii
write cm4-robot_raw.raw all
.endc

.end
