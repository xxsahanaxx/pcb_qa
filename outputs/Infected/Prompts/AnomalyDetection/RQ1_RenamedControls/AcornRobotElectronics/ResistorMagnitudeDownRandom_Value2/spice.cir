.title KiCad schematic

.model __D33 D

C7 0 Net-_U41-XTAL1_ 22pF
R66 Net-_U41-_RESET_ NET0121 10k
C80 0 NET0121 0.1uF
C24 0 NET0121 0.1uF
C29 Net-_U41-XTAL2_ 0 22pF
C9 0 Net-_U48-XTAL1_ 22pF
C33 Net-_U48-XTAL2_ 0 22pF
R3 Net-_U48-_RESET_ NET0121 10k
R27 NET0078 NET0121 1k
R96 NET0086 NET0121 1k
R72 /NET0105 NET0179 10k
C63 +3V3 0 0.1uF
R34 0 Net-_U30-SDO/SA1_ 5.1k
C6 Net-_U30-C1_ 0 0.1uF
C70 +3V3 0 0.1uF
C82 +3V3 0 1uF
C17 +5V 0 4.7uF
C25 +5V 0 1000uF
R21 NET0179 NET0168 2.2k
R53 +3V3 NET0003 10k
R5 NET0168 0 2.2k
R9 Net-_D30-K_ Net-_D5-A_ 51k
C52 VOUTP 0 47uF
D33 VOUTP Net-_D33-K_ __D33
R75 VOUTN Net-_D30-K_ 249k
R22 Net-_D26-K_ NET0031 470
R59 VOUTN VOUTP 24k
R13 +3V3 Net-_D11-A_ 56
C53 VOUTP VOUTN 0.1uF
R26 0 /NET0137 10k
R50 Net-_D19-K_ Net-_U51-Y_ 1k
R82 +3V3 Net-_D40-A_ 27
C37 5V_switched 0 0.1uF
R80 NET0111 Net-_D43-K_ 1k
R97 0 Net-_D36-K_ 200
C28 5V_switched 0 1uF
C26 +12V 0 1uF
C57 +3V3 0 10uF
C54 +5V 0 10uF
C22 +12V NET0092 22pF
R29 NET0092 +12V 1.8Meg
L3 +5V Net-_D9-A_ 10u
R56 0 NET0092 205k
C40 0 +3V3 0.1uF
C45 0 +3V3 0.1uF
R30 Net-_D42-K_ NET0143 470
R39 Net-_C23-Pad2_ Net-_C12-Pad1_ 75R
R63 Net-_C58-Pad2_ Net-_C12-Pad1_ 75R
C58 NET0077 Net-_C58-Pad2_ 22nF
C15 0 Net-_C15-Pad2_ 0.1uF
R57 Net-_C1-Pad2_ Net-_C12-Pad1_ 75R
R46 Net-_C73-Pad2_ Net-_C12-Pad1_ 75R
C12 Net-_C12-Pad1_ 0 1nF
C1 NET0187 Net-_C1-Pad2_ 22nF
C73 NET0057 Net-_C73-Pad2_ 22nF
C23 NET0019 Net-_C23-Pad2_ 22nF
C4 Net-_U54-OSC1_ 0 18pF
C55 Net-_U54-OSC2_ 0 18pF
C78 Net-_U32-OSC2_ 0 18pF
C71 0 NET0121 0.1uF
C21 NET0121 0 0.1uF
C48 0 5V_switched_CAN 0.1uF
R23 /NET0181 Net-_R23-Pad2_ 120
C47 0 5V_switched_CAN 0.1uF
R7 /NET0035 Net-_R7-Pad2_ 120
C10 0 NET0121 0.1uF
R94 Net-_U54-_RESET_ NET0121 10k
C32 Net-_U32-OSC1_ 0 18pF
R25 Net-_U32-_RESET_ NET0121 10k
C46 NET0121 0 0.1uF
C75 VMOT 0 47uF
C35 VMOT 0 4.7uF
R31 VMOT /NET0001 100k
C68 VMOT 0 0.1uF
R85 Net-_J25-CC2_ 0 5.1k
R71 0 Net-_J25-CC1_ 5.1k
C14 +5V 0 47uF
C31 VMOT 0 47uF
L2 Net-_D47-K_ +5V 100u
C66 +5V 0 47uF
R81 +5V Net-_Q1-G_ 10k
R54 5V_CAN_ENABLE Net-_JP24-A_ 10k
R89 +3V3 Net-_U10-A_ 10k
R12 +5V Net-_Q8-D_ 10k
R18 Net-_D45-K_ Net-_U11-A_ 130
R73 NET0191 +3V3 2.2k
R86 +3V3 Net-_U11-A_ 10k
R90 NET0200 +3V3 2.2k
C41 +3V3 0 0.1uF
C74 +3V3 0 470uF
R19 0 Net-_JP6-B_ 5.1k
C84 3.3V_PI_OUT 0 0.1uF
R92 3.3V_PI_OUT NET0176 10k
R33 3.3V_PI_OUT NET0125 10k
R58 NET0214 /NET0026 27
R45 +3V3 NET0102 10k
C60 +3V3 0 0.1uF
R70 NET0021 /NET0005 27
R8 +3V3 NET0141 10k
R76 +3V3 NET0155 10k
R44 NET0056 Net-_Q6-G_ 100
R65 NET0099 Net-_Q13-G_ 100
R20 NET0190 Net-_Q2-G_ 100
R67 NET0054 Net-_Q14-G_ 100
C86 +5V 0 0.1uF
C64 /NET0089 0 0.1uF
C72 +5V 0 10uF
C67 +5V 0 10uF
R2 VMOT Net-_R2-Pad2_ 50k
R102 Net-_D13-K_ Net-_U10-A_ 130
R55 NET0186 +3V3 2.2k
R88 Net-_D27-K1_ 0 130
R28 Net-_D27-K2_ NET0094 130
R99 /NET0205 +3V3 2.2k
C43 +3V3 0 0.1uF
R78 /NET0070 0 5.1k
R77 Net-_R2-Pad2_ /NET0070 50k
C11 0 +3V3 1uF
R95 +3V3 /NET0075 10k
R101 Net-_D48-K_ /NET0205 130
R83 +3V3 /NET0205 10k

V_12V +12V 0 DC 12.0
V_3V3 +3V3 0 DC 3.3
V_5V +5V 0 DC 5.0

.control
tran 100u 10m
set filetype=ascii
write cm4-robot_raw.raw all
.endc

.end
