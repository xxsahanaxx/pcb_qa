.title KiCad schematic

.model __D19 D

C75 0 Net-_U40-XTAL1_ 22pF
R92 Net-_U40-_RESET_ NET0042 10k
C35 0 NET0042 0.1uF
C53 0 NET0042 0.1uF
C62 Net-_U40-XTAL2_ 0 22pF
C9 0 Net-_U6-XTAL1_ 22pF
C46 Net-_U6-XTAL2_ 0 22pF
R43 Net-_U6-_RESET_ NET0042 10k
R91 NET0050 NET0042 1k
R14 NET0117 NET0042 1k
R18 /NET0104 NET0173 10k
C31 +3V3 0 0.1uF
R36 0 Net-_U1-SDO/SA1_ 5.1k
C14 Net-_U1-C1_ 0 0.1uF
C40 +3V3 0 1uF
C15 +3V3 0 0.1uF
C55 +5V 0 4.7uF
C28 +5V 0 1000uF
R16 NET0173 NET0157 2.2k
R40 +3V3 NET0095 10k
R70 NET0157 0 2.2k
R30 Net-_D44-K_ Net-_D43-A_ 51k
C30 VOUTP 0 47uF
D19 VOUTP Net-_D19-K_ __D19
R86 VOUTN Net-_D44-K_ 249k
R85 Net-_D35-K_ NET0098 470
R71 VOUTN VOUTP 24k
R3 +3V3 Net-_D36-A_ 56
C10 VOUTP VOUTN 0.1uF
R7 0 /NET0133 10k
R12 Net-_D37-K_ Net-_U30-Y_ 1k
R39 +3V3 Net-_D39-A_ 27
C67 5V_switched 0 0.1uF
R60 NET0125 Net-_D10-K_ 1k
R72 0 Net-_D16-K_ 200
C25 5V_switched 0 1uF
C56 +12V 0 1uF
C59 +3V3 0 10uF
C11 +5V 0 10uF
C23 +12V NET0193 22pF
R64 NET0193 +12V 1.8Meg
L1 +5V Net-_D30-A_ 10u
R32 0 NET0193 205k
C58 0 +3V3 0.1uF
C51 0 +3V3 0.1uF
R1 Net-_D49-K_ NET0061 470
R101 Net-_C48-Pad2_ Net-_C17-Pad1_ 75R
R20 Net-_C27-Pad2_ Net-_C17-Pad1_ 75R
C27 NET0198 Net-_C27-Pad2_ 22nF
C21 0 Net-_C21-Pad2_ 0.1uF
R58 Net-_C4-Pad2_ Net-_C17-Pad1_ 75R
R59 Net-_C1-Pad2_ Net-_C17-Pad1_ 75R
C17 Net-_C17-Pad1_ 0 1nF
C4 NET0103 Net-_C4-Pad2_ 22nF
C1 NET0075 Net-_C1-Pad2_ 22nF
C48 NET0009 Net-_C48-Pad2_ 22nF
C34 Net-_U20-OSC1_ 0 18pF
C66 Net-_U20-OSC2_ 0 18pF
C84 Net-_U55-OSC2_ 0 18pF
C6 0 NET0042 0.1uF
C24 NET0042 0 0.1uF
C81 0 5V_switched_CAN 0.1uF
R96 /NET0165 Net-_R96-Pad2_ 120
C76 0 5V_switched_CAN 0.1uF
R13 /NET0155 Net-_R13-Pad2_ 120
C72 0 NET0042 0.1uF
R35 Net-_U20-_RESET_ NET0042 10k
C3 Net-_U55-OSC1_ 0 18pF
R56 Net-_U55-_RESET_ NET0042 10k
C50 NET0042 0 0.1uF
C60 VMOT 0 47uF
C42 VMOT 0 4.7uF
R29 VMOT /NET0141 100k
C19 VMOT 0 0.1uF
R98 Net-_J18-CC2_ 0 5.1k
R53 0 Net-_J18-CC1_ 5.1k
C54 +5V 0 47uF
C32 VMOT 0 47uF
L2 Net-_D2-K_ +5V 100u
C41 +5V 0 47uF
R28 +5V Net-_Q12-G_ 10k
R77 5V_CAN_ENABLE Net-_JP5-A_ 10k
R5 +3V3 Net-_U19-A_ 10k
R17 +5V Net-_Q16-G_ 10k
R99 Net-_D24-K_ Net-_U23-A_ 130
R21 NET0024 +3V3 2.2k
R15 +3V3 Net-_U23-A_ 10k
R27 NET0089 +3V3 2.2k
C61 +3V3 0 0.1uF
C5 +3V3 0 470uF
R22 0 Net-_JP9-B_ 5.1k
C68 3.3V_PI_OUT 0 0.1uF
R8 3.3V_PI_OUT NET0033 10k
R66 3.3V_PI_OUT NET0161 10k
R67 NET0085 /NET0189 27
R84 +3V3 NET0084 10k
C13 +3V3 0 0.1uF
R23 NET0067 /NET0004 27
R82 +3V3 NET0136 10k
R54 +3V3 NET0124 10k
R95 NET0187 Net-_Q13-G_ 100
R62 NET0035 Net-_Q11-G_ 100
R78 NET0115 Net-_Q5-G_ 100
R41 NET0214 Net-_Q6-G_ 100
C80 +5V 0 0.1uF
C45 /NET0001 0 0.1uF
C16 +5V 0 10uF
C86 +5V 0 10uF
R26 VMOT Net-_R26-Pad2_ 50k
R87 Net-_D42-K_ Net-_U19-A_ 130
R88 NET0139 +3V3 2.2k
R33 Net-_D7-K1_ 0 130
R65 Net-_D7-K2_ NET0060 130
R52 /NET0184 +3V3 2.2k
C43 +3V3 0 0.1uF
R24 /NET0153 0 5.1k
R63 Net-_R26-Pad2_ /NET0153 50k
C77 0 +3V3 1uF
R69 +3V3 /NET0086 10k
R74 Net-_D9-K_ /NET0184 130
R75 +3V3 /NET0184 10k

V_12V +12V 0 DC 12.0
V_3V3 +3V3 0 DC 3.3
V_5V +5V 0 DC 5.0

.control
tran 100u 10m
set filetype=ascii
write cm4-robot_raw.raw all
.endc

.end
