.title KiCad schematic

.model __D6 D

C48 0 Net-_U5-XTAL1_ 22pF
R95 Net-_U5-_RESET_ NET0050 10k
C20 0 NET0050 0.1uF
C41 0 NET0050 0.1uF
C62 Net-_U5-XTAL2_ 0 22pF
C76 0 Net-_U20-XTAL1_ 22pF
C36 Net-_U20-XTAL2_ 0 22pF
R77 Net-_U20-_RESET_ NET0050 10k
R29 NET0203 NET0050 1k
R27 NET0093 NET0050 1k
R100 /NET0198 NET0106 10k
C13 +3V3 0 0.1uF
R70 0 Net-_U36-SDO/SA1_ 5.1k
C70 Net-_U36-C1_ 0 0.1uF
C6 +3V3 0 1uF
C25 +3V3 0 0.1uF
C75 +5V 0 4.7uF
C57 +5V 0 1000uF
R20 NET0106 NET0047 2.2k
R73 +3V3 NET0157 10k
R40 NET0047 0 2.2k
R62 Net-_D38-K_ Net-_D22-A_ 51k
C45 VOUTP 0 47uF
D6 VOUTP Net-_D6-K_ __D6
R93 VOUTN Net-_D38-K_ 249k
R16 Net-_D18-K_ NET0068 470
R22 VOUTN VOUTP 24k
R25 +3V3 Net-_D5-A_ 56
C74 VOUTP VOUTN 0.1uF
R19 0 /NET0084 10k
R52 Net-_D37-K_ Net-_U6-Y_ 1k
R3 +3V3 Net-_D15-A_ 27
C43 5V_switched 0 0.1uF
R39 NET0083 Net-_D32-K_ 1k
R81 0 Net-_D26-K_ 200
C56 5V_switched 0 1uF
C51 +12V 0 1uF
C50 +3V3 0 10uF
C67 +5V 0 10uF
C86 +12V NET0155 22pF
R67 NET0155 +12V 1.8Meg
L3 +5V Net-_D44-A_ 10u
R4 0 NET0155 205k
C53 0 +3V3 0.1uF
C61 0 +3V3 0.1uF
R76 Net-_D20-K_ NET0056 470
R63 Net-_C46-Pad2_ Net-_C79-Pad1_ 75R
R1 Net-_C38-Pad2_ Net-_C79-Pad1_ 75R
C38 NET0105 Net-_C38-Pad2_ 22nF
C3 0 Net-_C3-Pad2_ 0.1uF
R21 Net-_C72-Pad2_ Net-_C79-Pad1_ 75R
R17 Net-_C63-Pad2_ Net-_C79-Pad1_ 75R
C79 Net-_C79-Pad1_ 0 1nF
C72 NET0046 Net-_C72-Pad2_ 22nF
C63 NET0204 Net-_C63-Pad2_ 22nF
C46 NET0135 Net-_C46-Pad2_ 22nF
C1 Net-_U10-OSC1_ 0 18pF
C15 Net-_U10-OSC2_ 0 18pF
C12 Net-_U3-OSC2_ 0 18pF
C33 0 NET0050 0.1uF
C31 NET0050 0 0.1uF
C82 0 5V_switched_CAN 0.1uF
R60 /NET0121 Net-_R60-Pad2_ 120
C22 0 5V_switched_CAN 0.1uF
R54 /NET0010 Net-_R54-Pad2_ 120
C84 0 NET0050 0.1uF
R91 Net-_U10-_RESET_ NET0050 10k
C80 Net-_U3-OSC1_ 0 18pF
R8 Net-_U3-_RESET_ NET0050 10k
C65 NET0050 0 0.1uF
C81 VMOT 0 47uF
C29 VMOT 0 4.7uF
R38 VMOT /NET0015 100k
C9 VMOT 0 0.1uF
R24 Net-_J4-CC2_ 0 5.1k
R32 0 Net-_J4-CC1_ 5.1k
C77 +5V 0 47uF
C69 VMOT 0 47uF
L2 Net-_D30-K_ +5V 100u
C4 +5V 0 47uF
R56 +5V Net-_Q10-G_ 10k
R83 5V_CAN_ENABLE Net-_JP18-A_ 10k
R82 +3V3 Net-_U13-Y_ 10k
R30 +5V Net-_Q11-D_ 10k
R86 Net-_D39-K_ Net-_U13-A_ 130
R57 NET0210 +3V3 2.2k
R47 +3V3 Net-_U13-A_ 10k
R64 NET0058 +3V3 2.2k
C7 +3V3 0 0.1uF
C37 +3V3 0 470uF
R49 0 Net-_JP5-B_ 5.1k
C34 3.3V_PI_OUT 0 0.1uF
R2 3.3V_PI_OUT NET0114 10k
R18 3.3V_PI_OUT NET0197 10k
R71 NET0100 /NET0033 27
R72 +3V3 NET0207 10k
C5 +3V3 0 0.1uF
R35 NET0030 /NET0064 27
R13 +3V3 NET0126 10k
R97 +3V3 NET0079 10k
R102 NET0091 Net-_Q13-G_ 100
R10 NET0116 Net-_Q14-G_ 100
R48 NET0067 Net-_Q5-G_ 100
R45 NET0194 Net-_Q9-G_ 100
C83 +5V 0 0.1uF
C40 /NET0181 0 0.1uF
C55 +5V 0 10uF
C73 +5V 0 10uF
R80 VMOT Net-_R50-Pad1_ 50k
R65 Net-_D36-K_ Net-_U13-Y_ 130
R26 NET0163 +3V3 2.2k
R66 Net-_D4-K1_ 0 130
R101 Net-_D4-K2_ NET0176 130
R68 /NET0184 +3V3 2.2k
C66 +3V3 0 0.1uF
R42 /NET0143 0 5.1k
R50 Net-_R50-Pad1_ /NET0143 50k
C19 0 +3V3 1uF
R78 +3V3 /NET0045 10k
R14 Net-_D19-K_ /NET0184 130
R33 +3V3 /NET0184 10k

V_12V +12V 0 DC 12.0
V_3V3 +3V3 0 DC 3.3
V_5V +5V 0 DC 5.0

.control
tran 100u 10m
set filetype=ascii
write cm4-robot_raw.raw all
.endc

.end
