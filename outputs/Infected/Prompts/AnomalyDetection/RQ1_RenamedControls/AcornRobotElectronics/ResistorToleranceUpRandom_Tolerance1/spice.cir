.title KiCad schematic

.model __D24 D

C83 0 Net-_U44-XTAL1_ 22pF
R32 Net-_U44-_RESET_ NET0202 10k
C86 0 NET0202 0.1uF
C36 0 NET0202 0.1uF
C23 Net-_U44-XTAL2_ 0 22pF
C64 0 Net-_U11-XTAL1_ 22pF
C11 Net-_U11-XTAL2_ 0 22pF
R2 Net-_U11-_RESET_ NET0202 10k
R22 NET0067 NET0202 1k
R72 NET0142 NET0202 1k
R44 /NET0118 NET0148 10k
C26 +3V3 0 0.1uF
R61 0 Net-_U2-SDO/SA1_ 5.1k
C18 Net-_U2-C1_ 0 0.1uF
C80 +3V3 0 1uF
C20 +3V3 0 0.1uF
C81 +5V 0 4.7uF
C39 +5V 0 1000uF
R93 NET0148 NET0178 2.2k
R23 +3V3 NET0057 10k
R46 NET0178 0 2.2k
R10 Net-_D42-K_ Net-_D37-A_ 51k
C5 VOUTP 0 47uF
D24 VOUTP Net-_D24-K_ __D24
R68 VOUTN Net-_D42-K_ 249k
R1 Net-_D27-K_ NET0204 470
R5 VOUTN VOUTP 24k
R45 +3V3 Net-_D26-A_ 56
C84 VOUTP VOUTN 0.1uF
R70 0 /NET0083 10k
R48 Net-_D9-K_ Net-_U40-Y_ 1k
R47 +3V3 Net-_D41-A_ 27
C3 5V_switched 0 0.1uF
R77 NET0130 Net-_D8-K_ 1k
R78 0 Net-_D40-K_ 200
C31 5V_switched 0 1uF
C79 +12V 0 1uF
C15 +3V3 0 10uF
C34 +5V 0 10uF
C24 +12V NET0085 22pF
R12 NET0085 +12V 1.8Meg
L3 +5V Net-_D12-A_ 10u
R14 0 NET0085 205k
C49 0 +3V3 0.1uF
C48 0 +3V3 0.1uF
R50 Net-_D15-K_ NET0105 470
R49 Net-_C69-Pad2_ Net-_C40-Pad1_ 75R
R94 Net-_C59-Pad2_ Net-_C40-Pad1_ 75R
C59 NET0107 Net-_C59-Pad2_ 22nF
C85 0 Net-_C85-Pad2_ 0.1uF
R87 Net-_C54-Pad2_ Net-_C40-Pad1_ 75R
R79 Net-_C45-Pad2_ Net-_C40-Pad1_ 75R
C40 Net-_C40-Pad1_ 0 1nF
C54 NET0150 Net-_C54-Pad2_ 22nF
C45 NET0177 Net-_C45-Pad2_ 22nF
C69 NET0114 Net-_C69-Pad2_ 22nF
C29 Net-_U9-OSC1_ 0 18pF
C55 Net-_U9-OSC2_ 0 18pF
C28 Net-_U47-OSC2_ 0 18pF
C35 0 NET0202 0.1uF
C62 NET0202 0 0.1uF
C57 0 5V_switched_CAN 0.1uF
R88 /NET0001 Net-_R88-Pad2_ 120
C78 0 5V_switched_CAN 0.1uF
R28 /NET0193 Net-_R28-Pad2_ 120
C1 0 NET0202 0.1uF
R4 Net-_U9-_RESET_ NET0202 10k
C17 Net-_U47-OSC1_ 0 18pF
R76 Net-_U47-_RESET_ NET0202 10k
C6 NET0202 0 0.1uF
C50 VMOT 0 47uF
C30 VMOT 0 4.7uF
R24 VMOT /NET0096 100k
C16 VMOT 0 0.1uF
R69 Net-_J27-CC2_ 0 5.1k
R18 0 Net-_J27-CC1_ 5.1k
C65 +5V 0 47uF
C32 VMOT 0 47uF
L2 Net-_D30-K_ +5V 100u
C60 +5V 0 47uF
R84 +5V Net-_Q2-G_ 10k
R59 5V_CAN_ENABLE Net-_JP2-A_ 10k
R8 +3V3 Net-_U41-Y_ 10k
R41 +5V Net-_Q14-D_ 10k
R64 Net-_D1-K_ Net-_U41-A_ 130
R36 NET0062 +3V3 2.2k
R33 +3V3 Net-_U41-A_ 10k
R82 NET0146 +3V3 2.2k
C63 +3V3 0 0.1uF
C4 +3V3 0 470uF
R56 0 Net-_JP9-B_ 5.1k
R81 NET0120 /NET0089 27
R37 +3V3 NET0214 10k
C38 +3V3 0 0.1uF
R11 NET0028 /NET0213 27
R62 +3V3 NET0110 10k
R97 NET0111 Net-_Q9-G_ 100
R52 NET0081 Net-_Q1-G_ 100
R75 NET0071 Net-_Q16-G_ 100
R83 NET0168 Net-_Q6-G_ 100
R91 +3V3 NET0209 10k
C22 3.3V_PI_OUT 0 0.1uF
R102 3.3V_PI_OUT NET0006 10k
R80 3.3V_PI_OUT NET0205 10k
C2 +5V 0 0.1uF
C68 /NET0208 0 0.1uF
C43 +5V 0 10uF
C14 +5V 0 10uF
R51 VMOT Net-_R51-Pad2_ 50k
R57 Net-_D47-K_ Net-_U41-Y_ 130
R54 NET0171 +3V3 2.2k
R3 Net-_D17-K1_ 0 130
R7 Net-_D17-K2_ NET0195 130
R35 /NET0070 +3V3 2.2k
C25 +3V3 0 0.1uF
R67 /NET0027 0 5.1k
R55 Net-_R51-Pad2_ /NET0027 50k
C44 0 +3V3 1uF
R26 +3V3 /NET0121 10k
R21 Net-_D46-K_ /NET0070 130
R19 +3V3 /NET0070 10k

V_12V +12V 0 DC 12.0
V_3V3 +3V3 0 DC 3.3
V_5V +5V 0 DC 5.0

.control
tran 100u 10m
set filetype=ascii
write cm4-robot_raw.raw all
.endc

.end
