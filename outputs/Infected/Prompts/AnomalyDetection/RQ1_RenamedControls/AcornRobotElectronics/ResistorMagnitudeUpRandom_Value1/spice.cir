.title KiCad schematic

.model __D25 D

C12 0 Net-_U30-XTAL1_ 22pF
R26 Net-_U30-_RESET_ NET0203 10k
C6 0 NET0203 0.1uF
C5 0 NET0203 0.1uF
C36 Net-_U30-XTAL2_ 0 22pF
C57 0 Net-_U47-XTAL1_ 22pF
C19 Net-_U47-XTAL2_ 0 22pF
R27 Net-_U47-_RESET_ NET0203 10k
R82 NET0081 NET0203 1k
R95 NET0071 NET0203 1k
R90 /NET0134 NET0095 10k
C38 +3V3 0 0.1uF
R49 0 Net-_U11-SDO/SA1_ 5.1k
C15 Net-_U11-C1_ 0 0.1uF
C13 +3V3 0 1uF
C16 +3V3 0 0.1uF
C21 +5V 0 4.7uF
C33 +5V 0 1000uF
R71 NET0095 NET0156 2.2k
R19 +3V3 NET0107 10k
R77 NET0156 0 2.2k
R56 Net-_D43-K_ Net-_D18-A_ 51k
C30 VOUTP 0 47uF
D25 VOUTP Net-_D25-K_ __D25
R17 VOUTN Net-_D43-K_ 249k
R53 Net-_D47-K_ NET0124 470
R55 VOUTN VOUTP 24k
R87 +3V3 Net-_D4-A_ 56
C18 VOUTP VOUTN 0.1uF
R24 0 /NET0127 10k
R58 Net-_D14-K_ Net-_U20-Y_ 1k
R51 +3V3 Net-_D44-A_ 27
C24 5V_switched 0 0.1uF
R32 NET0099 Net-_D40-K_ 1k
R2 0 Net-_D20-K_ 200
C79 5V_switched 0 1uF
C50 +12V 0 1uF
C32 +3V3 0 10uF
C26 +5V 0 10uF
C54 +12V NET0120 22pF
R12 NET0120 +12V 1.8Meg
L1 +5V Net-_D33-A_ 10u
R66 0 NET0120 205k
C2 0 +3V3 0.1uF
C37 0 +3V3 0.1uF
R37 Net-_D26-K_ NET0187 470
R50 Net-_C80-Pad2_ Net-_C46-Pad1_ 75R
R68 Net-_C28-Pad2_ Net-_C46-Pad1_ 75R
C28 NET0104 Net-_C28-Pad2_ 22nF
C42 0 Net-_C42-Pad2_ 0.1uF
R35 Net-_C60-Pad2_ Net-_C46-Pad1_ 75R
R73 Net-_C66-Pad2_ Net-_C46-Pad1_ 75R
C46 Net-_C46-Pad1_ 0 1nF
C60 NET0006 Net-_C60-Pad2_ 22nF
C66 NET0204 Net-_C66-Pad2_ 22nF
C80 NET0005 Net-_C80-Pad2_ 22nF
C70 Net-_U3-OSC1_ 0 18pF
C84 Net-_U3-OSC2_ 0 18pF
C48 Net-_U46-OSC2_ 0 18pF
C29 0 NET0203 0.1uF
C27 NET0203 0 0.1uF
C86 0 5V_switched_CAN 0.1uF
R18 /NET0082 Net-_R18-Pad2_ 120
C78 0 5V_switched_CAN 0.1uF
R28 /NET0170 Net-_R28-Pad2_ 120
C76 0 NET0203 0.1uF
R54 Net-_U3-_RESET_ NET0203 10k
C11 Net-_U46-OSC1_ 0 18pF
R96 Net-_U46-_RESET_ NET0203 10k
C65 NET0203 0 0.1uF
C55 VMOT 0 47uF
C71 VMOT 0 4.7uF
R100 VMOT /NET0179 100k
C44 VMOT 0 0.1uF
R85 Net-_J21-CC2_ 0 5.1k
R14 0 Net-_J21-CC1_ 5.1k
C7 +5V 0 47uF
C67 VMOT 0 47uF
L2 Net-_D49-K_ +5V 100u
C63 +5V 0 47uF
R91 +5V Net-_Q12-G_ 10k
R16 5V_CAN_ENABLE Net-_JP12-A_ 10k
R22 +3V3 Net-_U14-A_ 10k
R42 +5V Net-_Q15-D_ 10k
R39 Net-_D8-K_ Net-_U15-Y_ 130
R86 NET0021 +3V3 2.2k
R62 +3V3 Net-_U15-Y_ 10k
R98 NET0123 +3V3 2.2k
C77 +3V3 0 0.1uF
C75 +3V3 0 470uF
R63 0 Net-_JP15-B_ 5.1k
C3 3.3V_PI_OUT 0 0.1uF
R69 3.3V_PI_OUT NET0130 10k
R5 3.3V_PI_OUT NET0069 10k
R64 NET0189 /NET0148 27
R31 +3V3 NET0001 10k
C62 +3V3 0 0.1uF
R41 NET0017 /NET0097 27
R89 +3V3 NET0020 10k
R13 +3V3 NET0140 10k
R78 NET0117 Net-_Q11-G_ 100
R38 NET0211 Net-_Q14-G_ 100
R25 NET0157 Net-_Q8-G_ 100
R93 NET0133 Net-_Q16-G_ 100
C64 +5V 0 0.1uF
C23 /NET0093 0 0.1uF
C83 +5V 0 10uF
C34 +5V 0 10uF
R1 VMOT Net-_R1-Pad2_ 50k
R21 Net-_D12-K_ Net-_U14-A_ 130
R44 NET0041 +3V3 2.2k
R84 Net-_D9-K1_ 0 130
R80 Net-_D9-K2_ NET0138 130
R33 /NET0023 +3V3 2.2k
C20 +3V3 0 0.1uF
R23 /NET0015 0 5.1k
R99 Net-_R1-Pad2_ /NET0015 50k
C82 0 +3V3 1uF
R81 +3V3 /NET0064 10k
R7 Net-_D39-K_ /NET0023 130
R30 +3V3 /NET0023 10k

V_12V +12V 0 DC 12.0
V_3V3 +3V3 0 DC 3.3
V_5V +5V 0 DC 5.0

.control
tran 100u 10m
set filetype=ascii
write cm4-robot_raw.raw all
.endc

.end
