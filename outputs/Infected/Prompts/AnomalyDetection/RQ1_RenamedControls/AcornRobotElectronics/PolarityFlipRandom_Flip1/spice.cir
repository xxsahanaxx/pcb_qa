.title KiCad schematic

.model __D46 D

C70 0 Net-_U17-XTAL1_ 22pF
R58 Net-_U17-_RESET_ NET0132 10k
C19 0 NET0132 0.1uF
C2 0 NET0132 0.1uF
C84 Net-_U17-XTAL2_ 0 22pF
C43 0 Net-_U44-XTAL1_ 22pF
C77 Net-_U44-XTAL2_ 0 22pF
R16 Net-_U44-_RESET_ NET0132 10k
R95 NET0091 NET0132 1k
R48 NET0047 NET0132 1k
R30 /NET0143 NET0183 10k
C78 +3V3 0 0.1uF
R94 0 Net-_U50-SDO/SA1_ 5.1k
C41 Net-_U50-C1_ 0 0.1uF
C33 +3V3 0 1uF
C20 +3V3 0 0.1uF
C14 +5V 0 4.7uF
C64 +5V 0 1000uF
R31 NET0183 NET0032 2.2k
R72 NET0032 0 2.2k
R4 Net-_J11-CC2_ 0 5.1k
R75 +3V3 NET0001 10k
R27 Net-_D10-K_ Net-_D43-A_ 51k
C86 VOUTP 0 47uF
D46 VOUTP Net-_D46-K_ __D46
R80 VOUTN Net-_D10-K_ 249k
R26 Net-_D17-K_ NET0105 470
R39 VOUTN VOUTP 24k
R100 +3V3 Net-_D25-A_ 56
C16 VOUTP VOUTN 0.1uF
R17 0 /NET0191 10k
R47 Net-_D22-K_ Net-_U11-Y_ 1k
R34 +3V3 Net-_D13-A_ 27
C12 5V_switched 0 0.1uF
R21 NET0155 Net-_D28-K_ 1k
R61 0 Net-_D20-K_ 200
C9 5V_switched 0 1uF
C10 +12V 0 1uF
C79 +3V3 0 10uF
C61 +5V 0 10uF
C60 +12V NET0189 22pF
R29 NET0189 +12V 1.8Meg
L3 +5V Net-_D39-A_ 10u
R37 0 NET0189 205k
C40 0 +3V3 0.1uF
C25 0 +3V3 0.1uF
R96 Net-_D11-K_ NET0070 470
R32 Net-_C56-Pad2_ Net-_C76-Pad1_ 75R
R12 Net-_C67-Pad2_ Net-_C76-Pad1_ 75R
C67 NET0036 Net-_C67-Pad2_ 22nF
C21 0 Net-_C21-Pad2_ 0.1uF
R78 Net-_C62-Pad2_ Net-_C76-Pad1_ 75R
R66 Net-_C81-Pad2_ Net-_C76-Pad1_ 75R
C76 Net-_C76-Pad1_ 0 1nF
C62 NET0154 Net-_C62-Pad2_ 22nF
C81 NET0084 Net-_C81-Pad2_ 22nF
C56 NET0149 Net-_C56-Pad2_ 22nF
C23 Net-_U4-OSC1_ 0 18pF
C32 Net-_U4-OSC2_ 0 18pF
C22 Net-_U37-OSC2_ 0 18pF
C52 0 NET0132 0.1uF
C58 NET0132 0 0.1uF
C13 0 5V_switched_CAN 0.1uF
R81 /NET0020 Net-_R81-Pad2_ 120
C7 0 5V_switched_CAN 0.1uF
R53 /NET0192 Net-_R53-Pad2_ 120
C24 0 NET0132 0.1uF
R87 Net-_U4-_RESET_ NET0132 10k
C5 Net-_U37-OSC1_ 0 18pF
R89 Net-_U37-_RESET_ NET0132 10k
C3 NET0132 0 0.1uF
R69 0 Net-_J11-CC1_ 5.1k
C82 VMOT 0 47uF
C85 VMOT 0 4.7uF
R85 VMOT /NET0086 100k
C54 VMOT 0 0.1uF
C8 VMOT 0 47uF
C31 +5V 0 47uF
C65 +5V 0 47uF
L2 Net-_D49-K_ +5V 100u
R54 +5V Net-_Q5-G_ 10k
R57 5V_CAN_ENABLE Net-_JP8-A_ 10k
R36 +3V3 Net-_U29-A_ 10k
R15 +5V Net-_Q12-G_ 10k
R63 Net-_D16-K_ Net-_U26-Y_ 130
R25 NET0174 +3V3 2.2k
R7 +3V3 Net-_U26-Y_ 10k
R43 NET0014 +3V3 2.2k
C36 +3V3 0 0.1uF
C69 +3V3 0 470uF
R65 0 Net-_JP23-B_ 5.1k
C63 3.3V_PI_OUT 0 0.1uF
R55 3.3V_PI_OUT NET0142 10k
R76 3.3V_PI_OUT NET0187 10k
R44 NET0071 /NET0150 27
R19 +3V3 NET0005 10k
C34 +3V3 0 0.1uF
R23 NET0116 /NET0176 27
R77 +3V3 NET0178 10k
R51 +3V3 NET0170 10k
R84 NET0212 Net-_Q3-G_ 100
R102 NET0018 Net-_Q8-G_ 100
R90 NET0201 Net-_Q9-G_ 100
R79 NET0188 Net-_Q1-G_ 100
C73 +5V 0 0.1uF
C39 /NET0039 0 0.1uF
C53 +5V 0 10uF
C35 +5V 0 10uF
R82 VMOT Net-_R64-Pad1_ 50k
R68 Net-_D36-K_ Net-_U29-A_ 130
R28 NET0048 +3V3 2.2k
R93 Net-_D6-K1_ 0 130
R67 Net-_D6-K2_ NET0137 130
R2 /NET0030 +3V3 2.2k
C75 +3V3 0 0.1uF
R97 /NET0122 0 5.1k
R64 Net-_R64-Pad1_ /NET0122 50k
C6 0 +3V3 1uF
R56 +3V3 /NET0088 10k
R38 Net-_D27-K_ /NET0030 130
R98 +3V3 /NET0030 10k

V_12V +12V 0 DC 12.0
V_3V3 +3V3 0 DC 3.3
V_5V +5V 0 DC 5.0

.control
tran 100u 10m
set filetype=ascii
write cm4-robot_raw.raw all
.endc

.end
