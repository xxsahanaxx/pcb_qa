.title KiCad schematic

.model __D12 D

C85 0 Net-_U8-XTAL1_ 22pF
R36 Net-_U8-_RESET_ NET0024 10k
C53 0 NET0024 0.1uF
C84 0 NET0024 0.1uF
C27 Net-_U8-XTAL2_ 0 22pF
C83 0 Net-_U15-XTAL1_ 22pF
C26 Net-_U15-XTAL2_ 0 22pF
R67 Net-_U15-_RESET_ NET0024 10k
R29 NET0121 NET0024 1k
R31 NET0142 NET0024 1k
R91 /NET0040 NET0174 10k
C16 +3V3 0 0.1uF
R23 0 Net-_U57-SDO/SA1_ 5.1k
C3 Net-_U57-C1_ 0 0.1uF
C12 +3V3 0 0.1uF
C32 +3V3 0 1uF
C47 +5V 0 4.7uF
C35 +5V 0 1000uF
R81 NET0174 NET0187 2.2k
R51 +3V3 NET0124 10k
R94 NET0187 0 2.2k
R16 Net-_D32-K_ Net-_D22-A_ 51k
C21 VOUTP 0 47uF
D12 VOUTP Net-_D12-K_ __D12
R33 VOUTN Net-_D32-K_ 249k
R59 Net-_D18-K_ NET0132 470
R88 VOUTN VOUTP 24k
R27 +3V3 Net-_D1-A_ 56
C81 VOUTP VOUTN 0.1uF
R43 0 /NET0192 10k
R41 Net-_D16-K_ Net-_U28-Y_ 1k
R92 +3V3 Net-_D34-A_ 27
C20 5V_switched 0 0.1uF
R13 NET0163 Net-_D23-K_ 1k
R25 0 Net-_D6-K_ 200
C30 5V_switched 0 1uF
C15 +12V 0 1uF
C60 +3V3 0 10uF
C59 +5V 0 10uF
C29 +12V NET0034 22pF
R46 NET0034 +12V 1.8Meg
L3 +5V Net-_D9-A_ 10u
R17 0 NET0034 205k
C4 0 +3V3 0.1uF
C2 0 +3V3 0.1uF
R49 Net-_D7-K_ NET0210 470
R60 Net-_C68-Pad2_ Net-_C48-Pad1_ 75R
R4 Net-_C24-Pad2_ Net-_C48-Pad1_ 75R
C24 NET0153 Net-_C24-Pad2_ 22nF
C86 0 Net-_C86-Pad2_ 0.1uF
R10 Net-_C44-Pad2_ Net-_C48-Pad1_ 75R
R34 Net-_C79-Pad2_ Net-_C48-Pad1_ 75R
C48 Net-_C48-Pad1_ 0 1nF
C44 NET0129 Net-_C44-Pad2_ 22nF
C79 NET0090 Net-_C79-Pad2_ 22nF
C68 NET0199 Net-_C68-Pad2_ 22nF
C37 Net-_U11-OSC1_ 0 18pF
C61 Net-_U11-OSC2_ 0 18pF
C19 Net-_U39-OSC2_ 0 18pF
C57 0 NET0024 0.1uF
C8 NET0024 0 0.1uF
C80 0 5V_switched_CAN 0.1uF
R90 /NET0092 Net-_R90-Pad2_ 120
C67 0 5V_switched_CAN 0.1uF
R72 /NET0160 Net-_R72-Pad2_ 120
C10 0 NET0024 0.1uF
R79 Net-_U11-_RESET_ NET0024 10k
C75 Net-_U39-OSC1_ 0 18pF
R56 Net-_U39-_RESET_ NET0024 10k
C52 NET0024 0 0.1uF
C69 VMOT 0 47uF
C58 VMOT 0 4.7uF
R47 VMOT /NET0207 100k
C7 VMOT 0 0.1uF
R48 Net-_J18-CC2_ 0 5.1k
R61 0 Net-_J18-CC1_ 5.1k
C62 +5V 0 47uF
C65 VMOT 0 47uF
L2 Net-_D21-K_ +5V 100u
C49 +5V 0 47uF
R35 +5V Net-_Q3-G_ 10k
R53 5V_CAN_ENABLE Net-_JP1-A_ 10k
R22 +3V3 Net-_U12-A_ 10k
R3 +5V Net-_Q12-G_ 10k
R64 Net-_D24-K_ Net-_U29-Y_ 130
R39 NET0134 +3V3 2.2k
R78 +3V3 Net-_U29-Y_ 10k
R19 NET0109 +3V3 2.2k
C17 +3V3 0 0.1uF
C45 +3V3 0 470uF
R71 0 Net-_JP4-B_ 5.1k
C74 3.3V_PI_OUT 0 0.1uF
R84 3.3V_PI_OUT NET0131 10k
R73 3.3V_PI_OUT NET0098 10k
R66 NET0099 /NET0011 27
R55 +3V3 NET0015 10k
C28 +3V3 0 0.1uF
R45 NET0003 /NET0214 27
R93 +3V3 NET0086 10k
R32 +3V3 NET0057 10k
R62 NET0065 Net-_Q1-G_ 100
R87 NET0006 Net-_Q10-G_ 100
R100 NET0067 Net-_Q8-G_ 100
R50 NET0097 Net-_Q16-G_ 100
C9 +5V 0 0.1uF
C51 /NET0128 0 0.1uF
C22 +5V 0 10uF
C66 +5V 0 10uF
R75 VMOT Net-_R24-Pad1_ 50k
R42 Net-_D43-K_ Net-_U12-A_ 130
R6 NET0104 +3V3 2.2k
R15 Net-_D40-K1_ 0 130
R9 Net-_D40-K2_ NET0149 130
R52 /NET0110 +3V3 2.2k
C39 +3V3 0 0.1uF
R101 /NET0197 0 5.1k
R24 Net-_R24-Pad1_ /NET0197 50k
C5 0 +3V3 1uF
R69 +3V3 /NET0122 10k
R68 Net-_D37-K_ /NET0110 130
R80 +3V3 /NET0110 10k

V_12V +12V 0 DC 12.0
V_3V3 +3V3 0 DC 3.3
V_5V +5V 0 DC 5.0

.control
tran 100u 10m
set filetype=ascii
write cm4-robot_raw.raw all
.endc

.end
