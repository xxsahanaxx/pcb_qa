.title KiCad schematic

.model __D3 D

C32 0 Net-_U35-XTAL1_ 22pF
R15 Net-_U35-_RESET_ NET0014 10k
C67 0 NET0014 0.1uF
C7 0 NET0014 0.1uF
C65 Net-_U35-XTAL2_ 0 22pF
C14 0 Net-_U25-XTAL1_ 22pF
C63 Net-_U25-XTAL2_ 0 22pF
R40 Net-_U25-_RESET_ NET0014 10k
R23 NET0099 NET0014 1k
R14 NET0007 NET0014 1k
R73 /NET0043 NET0040 10k
C54 +3V3 0 0.1uF
R63 0 Net-_U46-SDO/SA1_ 5.1k
C11 Net-_U46-C1_ 0 0.1uF
C52 +3V3 0 1uF
C55 +3V3 0 0.1uF
C26 +5V 0 4.7uF
C9 +5V 0 1000uF
R32 NET0040 NET0046 2.2k
R5 +3V3 NET0047 10k
R31 NET0046 0 2.2k
R2 Net-_D29-K_ Net-_D23-A_ 51k
C22 VOUTP 0 47uF
D3 VOUTP Net-_D3-K_ __D3
R26 VOUTN Net-_D29-K_ 249k
R13 Net-_D45-K_ NET0156 470
R48 VOUTN VOUTP 24k
R76 +3V3 Net-_D15-A_ 56
C57 VOUTP VOUTN 0.1uF
R28 0 /NET0066 10k
R55 Net-_D9-K_ Net-_U50-Y_ 1k
R99 +3V3 Net-_D17-A_ 27
C80 5V_switched 0 0.1uF
R75 NET0134 Net-_D40-K_ 1k
R60 0 Net-_D18-K_ 200
C12 5V_switched 0 1uF
C81 +12V 0 1uF
C6 +3V3 0 10uF
C3 +5V 0 10uF
C71 +12V NET0017 22pF
R44 NET0017 +12V 1.8Meg
L3 +5V Net-_D41-A_ 10u
R35 0 NET0017 205k
C17 0 +3V3 0.1uF
C58 0 +3V3 0.1uF
R42 Net-_D8-K_ NET0025 470
R53 Net-_C18-Pad2_ Net-_C72-Pad1_ 75R
R102 Net-_C70-Pad2_ Net-_C72-Pad1_ 75R
C70 NET0012 Net-_C70-Pad2_ 22nF
C29 0 Net-_C29-Pad2_ 0.1uF
R85 Net-_C34-Pad2_ Net-_C72-Pad1_ 75R
R6 Net-_C74-Pad2_ Net-_C72-Pad1_ 75R
C72 Net-_C72-Pad1_ 0 1nF
C34 NET0104 Net-_C34-Pad2_ 22nF
C74 NET0030 Net-_C74-Pad2_ 22nF
C18 NET0150 Net-_C18-Pad2_ 22nF
C2 Net-_U40-OSC1_ 0 18pF
C64 Net-_U40-OSC2_ 0 18pF
C60 Net-_U41-OSC2_ 0 18pF
C30 0 NET0014 0.1uF
C73 NET0014 0 0.1uF
C51 0 5V_switched_CAN 0.1uF
R77 /NET0091 Net-_R77-Pad2_ 120
C19 0 5V_switched_CAN 0.1uF
R20 /NET0108 Net-_R20-Pad2_ 120
C83 0 NET0014 0.1uF
R89 Net-_U40-_RESET_ NET0014 10k
C84 Net-_U41-OSC1_ 0 18pF
R4 Net-_U41-_RESET_ NET0014 10k
C24 NET0014 0 0.1uF
C36 VMOT 0 47uF
C44 VMOT 0 4.7uF
R68 VMOT /NET0077 100k
C5 VMOT 0 0.1uF
R25 Net-_J17-CC2_ 0 5.1k
R83 0 Net-_J17-CC1_ 5.1k
C77 +5V 0 47uF
C42 VMOT 0 47uF
L2 Net-_D35-K_ +5V 100u
C69 +5V 0 47uF
R1 +5V Net-_Q1-G_ 10k
R67 5V_CAN_ENABLE Net-_JP20-A_ 10k
R61 +3V3 Net-_U44-Y_ 10k
R10 +5V Net-_Q7-G_ 10k
R52 Net-_D4-K_ Net-_U13-Y_ 130
R17 NET0109 +3V3 2.2k
R91 +3V3 Net-_U13-Y_ 10k
R49 NET0035 +3V3 2.2k
C16 +3V3 0 0.1uF
C49 +3V3 0 470uF
R90 0 Net-_JP16-B_ 5.1k
R70 NET0181 /NET0114 27
R78 +3V3 NET0080 10k
C23 +3V3 0 0.1uF
R98 NET0112 /NET0055 27
R62 +3V3 NET0131 10k
R18 NET0167 Net-_Q10-G_ 100
R74 NET0096 Net-_Q8-G_ 100
R81 NET0029 Net-_Q11-G_ 100
R86 NET0063 Net-_Q5-G_ 100
R43 +3V3 NET0071 10k
C50 3.3V_PI_OUT 0 0.1uF
R36 3.3V_PI_OUT NET0001 10k
R56 3.3V_PI_OUT NET0067 10k
C48 +5V 0 0.1uF
C38 /NET0184 0 0.1uF
C56 +5V 0 10uF
C61 +5V 0 10uF
R82 VMOT Net-_R38-Pad1_ 50k
R16 Net-_D48-K_ Net-_U44-Y_ 130
R92 NET0068 +3V3 2.2k
R39 Net-_D16-K1_ 0 130
R8 Net-_D16-K2_ NET0196 130
R72 /NET0042 +3V3 2.2k
C39 +3V3 0 0.1uF
R21 /NET0157 0 5.1k
R38 Net-_R38-Pad1_ /NET0157 50k
C53 0 +3V3 1uF
R100 +3V3 /NET0203 10k
R95 Net-_D34-K_ /NET0042 130
R7 +3V3 /NET0042 10k

V_12V +12V 0 DC 12.0
V_3V3 +3V3 0 DC 3.3
V_5V +5V 0 DC 5.0

.control
tran 100u 10m
set filetype=ascii
write cm4-robot_raw.raw all
.endc

.end
