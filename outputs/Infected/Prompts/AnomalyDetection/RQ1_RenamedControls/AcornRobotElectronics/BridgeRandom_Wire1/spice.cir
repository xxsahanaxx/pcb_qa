.title KiCad schematic

.model __D36 D

C14 0 Net-_U25-XTAL1_ 22pF
R5 Net-_U25-_RESET_ NET0080 10k
C3 0 NET0080 0.1uF
C16 0 NET0080 0.1uF
C32 Net-_U25-XTAL2_ 0 22pF
C41 0 Net-_U7-XTAL1_ 22pF
C80 Net-_U7-XTAL2_ 0 22pF
R14 Net-_U7-_RESET_ NET0080 10k
R9 NET0124 NET0080 1k
R94 NET0149 NET0080 1k
R20 /NET0169 NET0162 10k
C12 +3V3 0 0.1uF
R18 0 Net-_U9-SDO/SA1_ 5.1k
C74 Net-_U9-C1_ 0 0.1uF
C35 +3V3 0 1uF
C69 +3V3 0 0.1uF
C78 +5V 0 4.7uF
C36 +5V 0 1000uF
R58 NET0162 NET0005 2.2k
R84 +3V3 NET0177 10k
R60 NET0005 0 2.2k
R63 Net-_D44-K_ Net-_D11-A_ 51k
C6 VOUTP 0 47uF
D36 VOUTP Net-_D36-K_ __D36
R64 VOUTN Net-_D44-K_ 249k
R82 Net-_D42-K_ NET0160 470
R17 VOUTN VOUTP 24k
R50 +3V3 Net-_D5-A_ 56
C81 VOUTP VOUTN 0.1uF
R90 0 /NET0131 10k
R45 Net-_D2-K_ Net-_U51-Y_ 1k
R69 +3V3 Net-_D46-A_ 27
C73 5V_switched 0 0.1uF
R73 NET0050 Net-_D37-K_ 1k
R97 0 Net-_D4-K_ 200
C21 5V_switched 0 1uF
C61 +12V 0 1uF
C25 +3V3 0 10uF
C70 +5V 0 10uF
C8 +12V NET0142 22pF
R70 NET0142 +12V 1.8Meg
L1 +5V Net-_D19-A_ 10u
R43 0 NET0142 205k
C7 0 +3V3 0.1uF
C27 0 +3V3 0.1uF
R98 Net-_D40-K_ NET0161 470
R91 Net-_C75-Pad2_ Net-_C19-Pad1_ 75R
R27 Net-_C86-Pad2_ Net-_C19-Pad1_ 75R
C86 NET0076 Net-_C86-Pad2_ 22nF
C85 0 Net-_C85-Pad2_ 0.1uF
R81 Net-_C51-Pad2_ Net-_C19-Pad1_ 75R
R13 Net-_C26-Pad2_ Net-_C19-Pad1_ 75R
C19 Net-_C19-Pad1_ 0 1nF
C51 NET0049 Net-_C51-Pad2_ 22nF
C26 NET0172 Net-_C26-Pad2_ 22nF
C75 NET0098 Net-_C75-Pad2_ 22nF
C22 Net-_U15-OSC1_ 0 18pF
C43 Net-_U15-OSC2_ 0 18pF
C76 Net-_U32-OSC2_ 0 18pF
C55 0 NET0080 0.1uF
C9 NET0080 0 0.1uF
C23 0 5V_switched_CAN 0.1uF
R52 /NET0066 Net-_R52-Pad2_ 120
C63 0 5V_switched_CAN 0.1uF
R30 /NET0163 Net-_R30-Pad2_ 120
C34 0 NET0080 0.1uF
R25 Net-_U15-_RESET_ NET0080 10k
C47 Net-_U32-OSC1_ 0 18pF
R33 Net-_U32-_RESET_ NET0080 10k
C49 NET0080 0 0.1uF
C65 VMOT 0 47uF
C66 VMOT 0 4.7uF
R68 VMOT /NET0090 100k
C37 VMOT 0 0.1uF
R78 Net-_J8-CC2_ 0 5.1k
R35 0 Net-_J8-CC1_ 5.1k
C11 +5V 0 47uF
C17 VMOT 0 47uF
L3 Net-_D47-K_ +5V 100u
C28 +5V 0 47uF
R85 +5V Net-_Q10-G_ 10k
R2 5V_CAN_ENABLE Net-_JP10-A_ 10k
R32 +3V3 Net-_U31-A_ 10k
R10 +5V Net-_Q16-G_ 10k
R102 Net-_D21-K_ Net-_U46-Y_ 130
R55 NET0070 +3V3 2.2k
R15 +3V3 Net-_U46-Y_ 10k
R93 NET0025 +3V3 2.2k
C56 +3V3 0 0.1uF
C83 +3V3 0 470uF
R6 0 Net-_JP13-B_ 5.1k
C10 3.3V_PI_OUT 0 0.1uF
R62 3.3V_PI_OUT NET0122 10k
R44 3.3V_PI_OUT NET0042 10k
R83 NET0024 /NET0006 27
R96 +3V3 NET0155 10k
C82 +3V3 0 0.1uF
R80 NET0130 /NET0168 27
R56 +3V3 NET0019 10k
R8 +3V3 NET0127 10k
R75 NET0063 Net-_Q12-G_ 100
R38 NET0187 Net-_Q7-G_ 100
R76 NET0140 Net-_Q8-G_ 100
R101 NET0166 Net-_Q1-G_ 100
C24 +5V 0 0.1uF
C2 /NET0135 0 0.1uF
C67 +5V 0 10uF
C20 +5V 0 10uF
R22 VMOT Net-_R100-Pad1_ 50k
R36 Net-_D14-K_ Net-_U31-A_ 130
R39 NET0165 +3V3 2.2k
R12 Net-_D49-K1_ 0 130
R49 Net-_D49-K2_ NET0095 130
R99 /NET0071 +3V3 2.2k
C29 +3V3 0 0.1uF
R37 /NET0101 0 5.1k
R100 Net-_R100-Pad1_ /NET0101 50k
C31 0 +3V3 1uF
R77 +3V3 /NET0041 10k
R87 Net-_D26-K_ /NET0071 130
R46 +3V3 /NET0071 10k

V_12V +12V 0 DC 12.0
V_3V3 +3V3 0 DC 3.3
V_5V +5V 0 DC 5.0

.control
tran 100u 10m
set filetype=ascii
write cm4-robot_raw.raw all
.endc

.end
