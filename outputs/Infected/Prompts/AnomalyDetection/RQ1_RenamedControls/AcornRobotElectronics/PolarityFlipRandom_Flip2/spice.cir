.title KiCad schematic

.model __D38 D

C22 0 Net-_U31-XTAL1_ 22pF
R80 Net-_U31-_RESET_ NET0045 10k
C27 0 NET0045 0.1uF
C74 0 NET0045 0.1uF
C41 Net-_U31-XTAL2_ 0 22pF
C17 0 Net-_U53-XTAL1_ 22pF
C11 Net-_U53-XTAL2_ 0 22pF
R10 Net-_U53-_RESET_ NET0045 10k
R61 NET0066 NET0045 1k
R53 NET0007 NET0045 1k
R60 /NET0122 NET0004 10k
C26 +3V3 0 0.1uF
R42 0 Net-_U37-SDO/SA1_ 5.1k
C52 Net-_U37-C1_ 0 0.1uF
C65 +3V3 0 1uF
C28 +3V3 0 0.1uF
C67 +5V 0 4.7uF
C72 +5V 0 1000uF
R63 NET0004 NET0079 2.2k
R45 +3V3 NET0018 10k
R54 NET0079 0 2.2k
R11 Net-_D34-K_ Net-_D10-A_ 51k
C50 VOUTP 0 47uF
D38 VOUTP Net-_D38-K_ __D38
R24 VOUTN Net-_D34-K_ 249k
R46 Net-_D6-K_ NET0057 470
R47 VOUTN VOUTP 24k
R85 +3V3 Net-_D15-A_ 56
C16 VOUTP VOUTN 0.1uF
R66 0 /NET0127 10k
R37 Net-_D47-K_ Net-_U19-Y_ 1k
R88 +3V3 Net-_D9-A_ 27
C77 5V_switched 0 0.1uF
R4 NET0131 Net-_D20-K_ 1k
R35 0 Net-_D23-K_ 200
C12 5V_switched 0 1uF
C13 +12V 0 1uF
C78 +3V3 0 10uF
C29 +5V 0 10uF
C84 +12V NET0035 22pF
R101 NET0035 +12V 1.8Meg
L1 +5V Net-_D29-A_ 10u
R94 0 NET0035 205k
C61 0 +3V3 0.1uF
C73 0 +3V3 0.1uF
R41 Net-_D30-K_ NET0044 470
R97 Net-_C82-Pad2_ Net-_C66-Pad1_ 75R
R12 Net-_C49-Pad2_ Net-_C66-Pad1_ 75R
C49 NET0186 Net-_C49-Pad2_ 22nF
C40 0 Net-_C40-Pad2_ 0.1uF
R57 Net-_C69-Pad2_ Net-_C66-Pad1_ 75R
R79 Net-_C70-Pad2_ Net-_C66-Pad1_ 75R
C66 Net-_C66-Pad1_ 0 1nF
C69 NET0144 Net-_C69-Pad2_ 22nF
C70 NET0013 Net-_C70-Pad2_ 22nF
C82 NET0202 Net-_C82-Pad2_ 22nF
C33 Net-_U44-OSC1_ 0 18pF
C24 Net-_U44-OSC2_ 0 18pF
C79 Net-_U40-OSC2_ 0 18pF
C37 0 NET0045 0.1uF
C18 NET0045 0 0.1uF
C86 0 5V_switched_CAN 0.1uF
R33 /NET0153 Net-_R33-Pad2_ 120
C76 0 5V_switched_CAN 0.1uF
R90 /NET0187 Net-_R90-Pad2_ 120
C64 0 NET0045 0.1uF
R3 Net-_U44-_RESET_ NET0045 10k
C20 Net-_U40-OSC1_ 0 18pF
R81 Net-_U40-_RESET_ NET0045 10k
C85 NET0045 0 0.1uF
C15 VMOT 0 47uF
C62 VMOT 0 4.7uF
R23 VMOT /NET0060 100k
C46 VMOT 0 0.1uF
R86 Net-_J34-CC2_ 0 5.1k
R92 0 Net-_J34-CC1_ 5.1k
C21 +5V 0 47uF
C25 VMOT 0 47uF
L3 Net-_D46-K_ +5V 100u
C30 +5V 0 47uF
R15 +5V Net-_Q14-G_ 10k
R76 5V_CAN_ENABLE Net-_JP4-A_ 10k
R99 +3V3 Net-_U14-A_ 10k
R21 +5V Net-_Q1-D_ 10k
R26 Net-_D35-K_ Net-_U32-Y_ 130
R70 NET0096 +3V3 2.2k
R59 +3V3 Net-_U32-Y_ 10k
R68 NET0158 +3V3 2.2k
C59 +3V3 0 0.1uF
C55 +3V3 0 470uF
R14 0 Net-_JP6-B_ 5.1k
R95 NET0177 /NET0009 27
R43 +3V3 NET0148 10k
C23 +3V3 0 0.1uF
R96 NET0050 /NET0163 27
R83 +3V3 NET0028 10k
R34 NET0188 Net-_Q15-G_ 100
R18 NET0161 Net-_Q7-G_ 100
R5 NET0112 Net-_Q10-G_ 100
R71 NET0011 Net-_Q13-G_ 100
R77 +3V3 NET0090 10k
C19 3.3V_PI_OUT 0 0.1uF
R6 3.3V_PI_OUT NET0166 10k
R65 3.3V_PI_OUT NET0132 10k
C5 +5V 0 0.1uF
C56 /NET0109 0 0.1uF
C7 +5V 0 10uF
C43 +5V 0 10uF
R1 VMOT Net-_R1-Pad2_ 50k
R20 Net-_D4-K_ Net-_U14-A_ 130
R69 NET0197 +3V3 2.2k
R29 Net-_D22-K1_ 0 130
R98 Net-_D22-K2_ NET0135 130
R87 /NET0143 +3V3 2.2k
C71 +3V3 0 0.1uF
R44 /NET0006 0 5.1k
R48 Net-_R1-Pad2_ /NET0006 50k
C81 0 +3V3 1uF
R73 +3V3 /NET0138 10k
R78 Net-_D43-K_ /NET0143 130
R2 +3V3 /NET0143 10k

V_12V +12V 0 DC 12.0
V_3V3 +3V3 0 DC 3.3
V_5V +5V 0 DC 5.0

.control
tran 100u 10m
set filetype=ascii
write cm4-robot_raw.raw all
.endc

.end
