.title KiCad schematic

.model __D15 D

C37 0 Net-_U8-XTAL1_ 22pF
R65 Net-_U8-_RESET_ NET0120 10k
C50 0 NET0120 0.1uF
C9 0 NET0120 0.1uF
C25 Net-_U8-XTAL2_ 0 22pF
C47 0 Net-_U13-XTAL1_ 22pF
C3 Net-_U13-XTAL2_ 0 22pF
R19 Net-_U13-_RESET_ NET0120 10k
R10 NET0006 NET0120 1k
R21 NET0039 NET0120 1k
R70 /NET0026 NET0190 10k
C83 +3V3 0 0.1uF
R86 0 Net-_U53-SDO/SA1_ 5.1k
C70 Net-_U53-C1_ 0 0.1uF
C63 +3V3 0 1uF
C39 +3V3 0 0.1uF
C61 +5V 0 4.7uF
C7 +5V 0 1000uF
R28 NET0190 NET0170 2.2k
R35 +3V3 NET0067 10k
R73 NET0170 0 2.2k
R38 Net-_D35-K_ Net-_D4-A_ 51k
C4 VOUTP 0 47uF
D15 VOUTP Net-_D15-K_ __D15
R56 VOUTN Net-_D35-K_ 249k
R76 Net-_D39-K_ NET0025 470
R67 VOUTN VOUTP 24k
R92 +3V3 Net-_D49-A_ 56
C1 VOUTP VOUTN 0.1uF
R75 0 /NET0114 10k
R11 Net-_D48-K_ Net-_U49-Y_ 1k
R50 +3V3 Net-_D21-A_ 27
C52 5V_switched 0 0.1uF
R87 NET0118 Net-_D33-K_ 1k
R60 0 Net-_D20-K_ 200
C44 5V_switched 0 1uF
C77 +12V 0 1uF
C5 +3V3 0 10uF
C28 +5V 0 10uF
C86 +12V NET0209 22pF
R74 NET0209 +12V 1.8Meg
L1 +5V Net-_D7-A_ 10u
R8 0 NET0209 205k
C10 0 +3V3 0.1uF
C29 0 +3V3 0.1uF
R54 Net-_D23-K_ NET0104 470
R7 Net-_C49-Pad2_ Net-_C6-Pad1_ 75R
R71 Net-_C22-Pad2_ Net-_C6-Pad1_ 75R
C22 NET0123 Net-_C22-Pad2_ 22nF
C65 0 Net-_C65-Pad2_ 0.1uF
R24 Net-_C56-Pad2_ Net-_C6-Pad1_ 75R
R12 Net-_C16-Pad2_ Net-_C6-Pad1_ 75R
C6 Net-_C6-Pad1_ 0 1nF
C56 NET0130 Net-_C56-Pad2_ 22nF
C16 NET0059 Net-_C16-Pad2_ 22nF
C49 NET0211 Net-_C49-Pad2_ 22nF
C72 Net-_U46-OSC1_ 0 18pF
C32 Net-_U46-OSC2_ 0 18pF
C18 Net-_U23-OSC2_ 0 18pF
C23 0 NET0120 0.1uF
C26 NET0120 0 0.1uF
C82 0 5V_switched_CAN 0.1uF
R82 /NET0101 Net-_R82-Pad2_ 120
C24 0 5V_switched_CAN 0.1uF
R34 /NET0063 Net-_R34-Pad2_ 120
C68 0 NET0120 0.1uF
R37 Net-_U46-_RESET_ NET0120 10k
C15 Net-_U23-OSC1_ 0 18pF
R99 Net-_U23-_RESET_ NET0120 10k
C67 NET0120 0 0.1uF
C13 VMOT 0 47uF
C46 VMOT 0 4.7uF
R43 VMOT /NET0162 100k
C41 VMOT 0 0.1uF
R29 Net-_J23-CC2_ 0 5.1k
R48 0 Net-_J23-CC1_ 5.1k
C45 +5V 0 47uF
C33 VMOT 0 47uF
L3 Net-_D36-K_ +5V 100u
C80 +5V 0 47uF
R25 +5V Net-_Q12-G_ 10k
R58 5V_CAN_ENABLE Net-_JP14-A_ 10k
R17 +3V3 Net-_U11-A_ 10k
R51 +5V Net-_Q3-D_ 10k
R100 Net-_D26-K_ Net-_U3-A_ 130
R63 NET0144 +3V3 2.2k
R31 +3V3 Net-_U3-A_ 10k
R55 NET0017 +3V3 2.2k
C14 +3V3 0 0.1uF
C57 +3V3 0 470uF
R62 0 Net-_JP18-B_ 5.1k
R40 NET0141 /NET0127 27
R64 +3V3 NET0159 10k
C81 +3V3 0 0.1uF
R88 NET0150 /NET0188 27
R68 +3V3 NET0116 10k
R18 NET0171 Net-_Q1-G_ 100
R89 NET0048 Net-_Q6-G_ 100
R79 NET0047 Net-_Q15-G_ 100
R36 NET0004 Net-_Q7-G_ 100
R16 +3V3 NET0020 10k
C62 3.3V_PI_OUT 0 0.1uF
R45 3.3V_PI_OUT NET0074 10k
R9 3.3V_PI_OUT NET0107 10k
C79 +5V 0 0.1uF
C20 /NET0152 0 0.1uF
C17 +5V 0 10uF
C35 +5V 0 10uF
R102 VMOT Net-_R102-Pad2_ 50k
R93 Net-_D37-K_ Net-_U11-A_ 130
R33 NET0100 +3V3 2.2k
R83 Net-_D34-K1_ 0 130
R22 Net-_D34-K2_ NET0075 130
R27 /NET0154 +3V3 2.2k
C34 +3V3 0 0.1uF
R101 /NET0105 0 5.1k
R32 Net-_R102-Pad2_ /NET0105 50k
C43 0 +3V3 1uF
R94 +3V3 /NET0058 10k
R98 Net-_D25-K_ /NET0154 130
R14 +3V3 /NET0154 10k

V_12V +12V 0 DC 12.0
V_3V3 +3V3 0 DC 3.3
V_5V +5V 0 DC 5.0

.control
tran 100u 10m
set filetype=ascii
write cm4-robot_raw.raw all
.endc

.end
