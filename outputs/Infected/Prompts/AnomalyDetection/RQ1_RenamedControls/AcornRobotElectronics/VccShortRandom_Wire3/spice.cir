.title KiCad schematic

.model __D35 D

C15 0 Net-_U11-XTAL1_ 22pF
R40 Net-_U11-_RESET_ NET0196 10k
C71 0 NET0196 0.1uF
C47 0 NET0196 0.1uF
C37 Net-_U11-XTAL2_ 0 22pF
C59 0 Net-_U48-XTAL1_ 22pF
C13 Net-_U48-XTAL2_ 0 22pF
R71 Net-_U48-_RESET_ NET0196 10k
R99 NET0089 NET0196 1k
R49 NET0009 NET0196 1k
R31 /NET0159 NET0186 10k
C73 +3V3 0 0.1uF
R67 0 Net-_U56-SDO/SA1_ 5.1k
C72 Net-_U56-C1_ 0 0.1uF
C85 +3V3 0 1uF
C38 +3V3 0 0.1uF
C14 +5V 0 4.7uF
C62 +5V 0 1000uF
R57 NET0186 NET0016 2.2k
R43 +3V3 NET0132 10k
R17 NET0016 0 2.2k
R84 Net-_D17-K_ Net-_D28-A_ 51k
C51 VOUTP 0 47uF
D35 VOUTP Net-_D35-K_ __D35
R18 VOUTN Net-_D17-K_ 249k
R19 Net-_D24-K_ NET0075 470
R96 VOUTN VOUTP 24k
R36 +3V3 Net-_D40-A_ 56
C27 VOUTP VOUTN 0.1uF
R75 0 /NET0135 10k
R102 Net-_D22-K_ Net-_U2-Y_ 1k
R29 +3V3 Net-_D41-A_ 27
C34 5V_switched 0 0.1uF
R58 NET0055 Net-_D25-K_ 1k
R59 0 Net-_D6-K_ 200
C36 5V_switched 0 1uF
C83 +12V 0 1uF
C30 +3V3 0 10uF
C80 +5V 0 10uF
C46 +12V NET0209 22pF
R62 NET0209 +12V 1.8Meg
L1 +5V Net-_D9-A_ 10u
R12 0 NET0209 205k
C4 0 +3V3 0.1uF
C39 0 +3V3 0.1uF
R44 Net-_D30-K_ NET0139 470
R95 Net-_C11-Pad2_ Net-_C28-Pad1_ 75R
R94 Net-_C65-Pad2_ Net-_C28-Pad1_ 75R
C65 NET0200 Net-_C65-Pad2_ 22nF
C29 0 Net-_C29-Pad2_ 0.1uF
R22 Net-_C23-Pad2_ Net-_C28-Pad1_ 75R
R82 Net-_C25-Pad2_ Net-_C28-Pad1_ 75R
C28 Net-_C28-Pad1_ 0 1nF
C23 NET0013 Net-_C23-Pad2_ 22nF
C25 NET0195 Net-_C25-Pad2_ 22nF
C11 NET0199 Net-_C11-Pad2_ 22nF
C74 Net-_U53-OSC1_ 0 18pF
C31 Net-_U53-OSC2_ 0 18pF
C64 Net-_U47-OSC2_ 0 18pF
C21 0 NET0196 0.1uF
C35 NET0196 0 0.1uF
C57 0 5V_switched_CAN 0.1uF
R88 /NET0207 Net-_R88-Pad2_ 120
C78 0 5V_switched_CAN 0.1uF
R1 /NET0166 Net-_R1-Pad2_ 120
C63 0 NET0196 0.1uF
R34 Net-_U53-_RESET_ NET0196 10k
C5 Net-_U47-OSC1_ 0 18pF
R16 Net-_U47-_RESET_ NET0196 10k
C52 NET0196 0 0.1uF
C20 VMOT 0 47uF
C18 VMOT 0 4.7uF
R25 VMOT /NET0048 100k
C42 VMOT 0 0.1uF
R41 Net-_J9-CC2_ 0 5.1k
R101 0 Net-_J9-CC1_ 5.1k
C82 +5V 0 47uF
C19 VMOT 0 47uF
L3 Net-_D47-K_ +5V 100u
C70 +5V 0 47uF
R61 +5V Net-_Q11-G_ 10k
R13 5V_CAN_ENABLE Net-_JP18-A_ 10k
R80 +3V3 Net-_U26-A_ 10k
R35 +5V Net-_Q16-G_ 10k
R64 Net-_D33-K_ Net-_U32-Y_ 130
R38 NET0100 +3V3 2.2k
R97 +3V3 Net-_U32-Y_ 10k
R11 NET0036 +3V3 2.2k
C40 +3V3 0 0.1uF
C24 +3V3 0 470uF
R9 0 Net-_JP3-B_ 5.1k
C77 3.3V_PI_OUT 0 0.1uF
R92 3.3V_PI_OUT NET0049 10k
R39 3.3V_PI_OUT NET0072 10k
R63 NET0158 /NET0136 27
R46 +3V3 NET0099 10k
C44 +3V3 0 0.1uF
R89 NET0213 /NET0084 27
R21 +3V3 NET0179 10k
R66 +3V3 NET0142 10k
R7 NET0026 Net-_Q4-G_ 100
R93 NET0062 Net-_Q14-G_ 100
R33 NET0056 Net-_Q1-G_ 100
R4 NET0171 Net-_Q7-G_ 100
C26 +5V 0 0.1uF
C8 /NET0197 0 0.1uF
C43 +5V 0 10uF
C66 +5V 0 10uF
R10 VMOT Net-_R10-Pad2_ 50k
R73 Net-_D31-K_ Net-_U26-A_ 130
R86 NET0105 +3V3 2.2k
R85 Net-_D20-K1_ 0 130
R54 Net-_D20-K2_ NET0067 130
R24 /NET0096 +3V3 2.2k
C6 +3V3 0 0.1uF
R15 /NET0068 0 5.1k
R28 Net-_R10-Pad2_ /NET0068 50k
C58 0 +3V3 1uF
R14 +3V3 /NET0119 10k
R53 Net-_D38-K_ /NET0096 130
R3 +3V3 /NET0096 10k

V_12V +12V 0 DC 12.0
V_3V3 +3V3 0 DC 3.3
V_5V +5V 0 DC 5.0

.control
tran 100u 10m
set filetype=ascii
write cm4-robot_raw.raw all
.endc

.end
