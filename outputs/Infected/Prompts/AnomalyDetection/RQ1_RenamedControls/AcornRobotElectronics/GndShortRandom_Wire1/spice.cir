.title KiCad schematic

.model __D29 D

C78 0 Net-_U1-XTAL1_ 22pF
R34 Net-_U1-_RESET_ NET0112 10k
C52 0 NET0112 0.1uF
C12 0 NET0112 0.1uF
C59 Net-_U1-XTAL2_ 0 22pF
C18 0 Net-_U40-XTAL1_ 22pF
C39 Net-_U40-XTAL2_ 0 22pF
R92 Net-_U40-_RESET_ NET0112 10k
R75 NET0002 NET0112 1k
R17 NET0007 NET0112 1k
R33 /NET0130 NET0066 10k
C28 +3V3 0 0.1uF
R49 0 Net-_U49-SDO/SA1_ 5.1k
C34 Net-_U49-C1_ 0 0.1uF
C80 +3V3 0 1uF
C37 +3V3 0 0.1uF
C23 +5V 0 4.7uF
C35 +5V 0 1000uF
R97 NET0066 NET0151 2.2k
R16 +3V3 NET0026 10k
R13 NET0151 0 2.2k
R88 Net-_D34-K_ Net-_D27-A_ 51k
C3 VOUTP 0 47uF
D29 VOUTP Net-_D29-K_ __D29
R46 VOUTN Net-_D34-K_ 249k
R74 Net-_D4-K_ NET0050 470
R91 VOUTN VOUTP 24k
R9 +3V3 Net-_D40-A_ 56
C79 VOUTP VOUTN 0.1uF
R1 0 /NET0086 10k
R100 Net-_D38-K_ Net-_U20-Y_ 1k
R27 +3V3 Net-_D44-A_ 27
C16 5V_switched 0 0.1uF
R102 NET0023 Net-_D12-K_ 1k
R39 0 Net-_D30-K_ 200
C60 5V_switched 0 1uF
C71 +12V 0 1uF
C9 +3V3 0 10uF
C26 +5V 0 10uF
C67 +12V NET0006 22pF
R11 NET0006 +12V 1.8Meg
L3 +5V Net-_D47-A_ 10u
R43 0 NET0006 205k
C61 0 +3V3 0.1uF
C42 0 +3V3 0.1uF
R22 Net-_D28-K_ NET0088 470
R47 Net-_C51-Pad2_ Net-_C33-Pad1_ 75R
R40 Net-_C53-Pad2_ Net-_C33-Pad1_ 75R
C53 NET0025 Net-_C53-Pad2_ 22nF
C19 0 Net-_C19-Pad2_ 0.1uF
R19 Net-_C86-Pad2_ Net-_C33-Pad1_ 75R
R42 Net-_C55-Pad2_ Net-_C33-Pad1_ 75R
C33 Net-_C33-Pad1_ 0 1nF
C86 NET0031 Net-_C86-Pad2_ 22nF
C55 NET0132 Net-_C55-Pad2_ 22nF
C51 NET0055 Net-_C51-Pad2_ 22nF
C32 Net-_U52-OSC1_ 0 18pF
C43 Net-_U52-OSC2_ 0 18pF
C64 Net-_U25-OSC2_ 0 18pF
C72 0 NET0112 0.1uF
C84 NET0112 0 0.1uF
C75 0 5V_switched_CAN 0.1uF
R24 /NET0170 Net-_R24-Pad2_ 120
C82 0 5V_switched_CAN 0.1uF
R79 /NET0194 Net-_R79-Pad2_ 120
C15 0 NET0112 0.1uF
R90 Net-_U52-_RESET_ NET0112 10k
C63 Net-_U25-OSC1_ 0 18pF
R76 Net-_U25-_RESET_ NET0112 10k
C20 NET0112 0 0.1uF
C73 VMOT 0 47uF
C47 VMOT 0 4.7uF
R61 VMOT /NET0138 100k
C31 VMOT 0 0.1uF
R66 Net-_J17-CC2_ 0 5.1k
R28 0 Net-_J17-CC1_ 5.1k
C30 +5V 0 47uF
C2 VMOT 0 47uF
L2 Net-_D10-K_ +5V 100u
C49 +5V 0 47uF
R4 +5V Net-_Q8-G_ 10k
R63 5V_CAN_ENABLE Net-_JP14-A_ 10k
R14 +3V3 Net-_U26-A_ 10k
R86 +5V Net-_Q1-G_ 10k
R69 Net-_D46-K_ Net-_U18-Y_ 130
R67 NET0156 +3V3 2.2k
R56 +3V3 Net-_U18-Y_ 10k
R12 NET0119 +3V3 2.2k
C13 +3V3 0 0.1uF
C62 +3V3 0 470uF
R99 0 Net-_JP5-B_ 5.1k
C25 3.3V_PI_OUT 0 0.1uF
R72 3.3V_PI_OUT NET0211 10k
R36 3.3V_PI_OUT NET0121 10k
R82 NET0096 /NET0044 27
R70 +3V3 NET0180 10k
C54 +3V3 0 0.1uF
R83 NET0098 /NET0125 27
R60 +3V3 NET0158 10k
R55 +3V3 NET0085 10k
R57 NET0093 Net-_Q15-G_ 100
R68 NET0157 Net-_Q10-G_ 100
R94 NET0192 Net-_Q7-G_ 100
R98 NET0089 Net-_Q6-G_ 100
C24 +5V 0 0.1uF
C45 /NET0186 0 0.1uF
C29 +5V 0 10uF
C4 +5V 0 10uF
R6 VMOT Net-_R23-Pad1_ 50k
R51 Net-_D26-K_ Net-_U26-A_ 130
R62 NET0038 +3V3 2.2k
R101 Net-_D22-K1_ 0 130
R52 Net-_D22-K2_ NET0078 130
R7 /NET0141 +3V3 2.2k
C69 +3V3 0 0.1uF
R50 /NET0115 0 5.1k
R23 Net-_R23-Pad1_ /NET0115 50k
C7 0 +3V3 1uF
R2 +3V3 /NET0079 10k
R41 Net-_D17-K_ /NET0141 130
R37 +3V3 /NET0141 10k

V_12V +12V 0 DC 12.0
V_3V3 +3V3 0 DC 3.3
V_5V +5V 0 DC 5.0

.control
tran 100u 10m
set filetype=ascii
write cm4-robot_raw.raw all
.endc

.end
