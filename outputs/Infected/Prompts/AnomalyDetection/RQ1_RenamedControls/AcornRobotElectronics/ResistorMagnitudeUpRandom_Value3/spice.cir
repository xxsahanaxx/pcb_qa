.title KiCad schematic

.model __D25 D

C59 0 Net-_U46-XTAL1_ 22pF
R74 Net-_U46-_RESET_ NET0114 10k
C62 0 NET0114 0.1uF
C47 0 NET0114 0.1uF
C73 Net-_U46-XTAL2_ 0 22pF
C74 0 Net-_U1-XTAL1_ 22pF
C56 Net-_U1-XTAL2_ 0 22pF
R54 Net-_U1-_RESET_ NET0114 10k
R50 NET0164 NET0114 1k
R13 NET0067 NET0114 1k
R15 /NET0198 NET0102 10k
C32 +3V3 0 0.1uF
R38 0 Net-_U44-SDO/SA1_ 5.1k
C43 Net-_U44-C1_ 0 0.1uF
C27 +3V3 0 1uF
C49 +3V3 0 0.1uF
C71 +5V 0 4.7uF
C19 +5V 0 1000uF
R102 NET0102 NET0178 2.2k
R86 +3V3 NET0037 10k
R99 NET0178 0 2.2k
R46 Net-_D32-K_ Net-_D38-A_ 51k
C69 VOUTP 0 47uF
D25 VOUTP Net-_D25-K_ __D25
R18 VOUTN Net-_D32-K_ 249k
R72 Net-_D46-K_ NET0074 470
R28 VOUTN VOUTP 24k
R77 +3V3 Net-_D8-A_ 56
C45 VOUTP VOUTN 0.1uF
R97 0 /NET0097 10k
R19 Net-_D44-K_ Net-_U19-Y_ 1k
R94 +3V3 Net-_D1-A_ 27
C40 5V_switched 0 0.1uF
R101 NET0126 Net-_D21-K_ 1k
R65 0 Net-_D18-K_ 200
C72 5V_switched 0 1uF
C58 +12V 0 1uF
C2 +3V3 0 10uF
C25 +5V 0 10uF
C28 +12V NET0163 22pF
R27 NET0163 +12V 1.8Meg
L3 +5V Net-_D4-A_ 10u
R39 0 NET0163 205k
C66 0 +3V3 0.1uF
C3 0 +3V3 0.1uF
R82 Net-_D35-K_ NET0187 470
R47 Net-_C52-Pad2_ Net-_C1-Pad1_ 75R
R44 Net-_C82-Pad2_ Net-_C1-Pad1_ 75R
C82 NET0026 Net-_C82-Pad2_ 22nF
C15 0 Net-_C15-Pad2_ 0.1uF
R95 Net-_C83-Pad2_ Net-_C1-Pad1_ 75R
R33 Net-_C60-Pad2_ Net-_C1-Pad1_ 75R
C1 Net-_C1-Pad1_ 0 1nF
C83 NET0029 Net-_C83-Pad2_ 22nF
C60 NET0058 Net-_C60-Pad2_ 22nF
C52 NET0027 Net-_C52-Pad2_ 22nF
C42 Net-_U33-OSC1_ 0 18pF
C44 Net-_U33-OSC2_ 0 18pF
C20 Net-_U11-OSC2_ 0 18pF
C79 0 NET0114 0.1uF
C54 NET0114 0 0.1uF
C80 0 5V_switched_CAN 0.1uF
R76 /NET0084 Net-_R76-Pad2_ 120
C67 0 5V_switched_CAN 0.1uF
R26 /NET0050 Net-_R26-Pad2_ 120
C38 0 NET0114 0.1uF
R48 Net-_U33-_RESET_ NET0114 10k
C34 Net-_U11-OSC1_ 0 18pF
R75 Net-_U11-_RESET_ NET0114 10k
C37 NET0114 0 0.1uF
C65 VMOT 0 47uF
C21 VMOT 0 4.7uF
R80 VMOT /NET0073 100k
C7 VMOT 0 0.1uF
R29 Net-_J23-CC2_ 0 5.1k
R21 0 Net-_J23-CC1_ 5.1k
C30 +5V 0 47uF
C70 VMOT 0 47uF
L2 Net-_D33-K_ +5V 100u
C55 +5V 0 47uF
R98 +5V Net-_Q8-G_ 10k
R78 5V_CAN_ENABLE Net-_JP11-A_ 10k
R32 +3V3 Net-_U14-A_ 10k
R79 +5V Net-_Q13-G_ 10k
R7 Net-_D19-K_ Net-_U20-A_ 130
R2 NET0091 +3V3 2.2k
R57 +3V3 Net-_U20-A_ 10k
R3 NET0121 +3V3 2.2k
C77 +3V3 0 0.1uF
C12 +3V3 0 470uF
R49 0 Net-_JP5-B_ 5.1k
R6 NET0158 /NET0066 27
R8 +3V3 NET0173 10k
C75 +3V3 0 0.1uF
R40 NET0160 /NET0210 27
R69 +3V3 NET0157 10k
R58 NET0136 Net-_Q7-G_ 100
R37 NET0057 Net-_Q3-G_ 100
R14 NET0100 Net-_Q10-G_ 100
R34 NET0002 Net-_Q2-G_ 100
R56 +3V3 NET0168 10k
C78 3.3V_PI_OUT 0 0.1uF
R68 3.3V_PI_OUT NET0112 10k
R88 3.3V_PI_OUT NET0017 10k
C6 +5V 0 0.1uF
C63 /NET0016 0 0.1uF
C50 +5V 0 10uF
C29 +5V 0 10uF
R59 VMOT Net-_R59-Pad2_ 50k
R42 Net-_D47-K_ Net-_U14-A_ 130
R35 NET0062 +3V3 2.2k
R93 Net-_D37-K1_ 0 130
R85 Net-_D37-K2_ NET0006 130
R63 /NET0141 +3V3 2.2k
C85 +3V3 0 0.1uF
R60 /NET0075 0 5.1k
R71 Net-_R59-Pad2_ /NET0075 50k
C14 0 +3V3 1uF
R90 +3V3 /NET0069 10k
R10 Net-_D5-K_ /NET0141 130
R81 +3V3 /NET0141 10k

V_12V +12V 0 DC 12.0
V_3V3 +3V3 0 DC 3.3
V_5V +5V 0 DC 5.0

.control
tran 100u 10m
set filetype=ascii
write cm4-robot_raw.raw all
.endc

.end
