.title KiCad schematic

.model __D7 D

C51 0 Net-_U25-XTAL1_ 22pF
R33 Net-_U25-_RESET_ NET0028 10k
C68 0 NET0028 0.1uF
C76 0 NET0028 0.1uF
C64 Net-_U25-XTAL2_ 0 22pF
C60 0 Net-_U16-XTAL1_ 22pF
C13 Net-_U16-XTAL2_ 0 22pF
R31 Net-_U16-_RESET_ NET0028 10k
R66 NET0097 NET0028 1k
R25 NET0155 NET0028 1k
R89 /NET0081 NET0213 10k
C31 +3V3 0 0.1uF
R4 0 Net-_U15-SDO/SA1_ 5.1k
C83 Net-_U15-C1_ 0 0.1uF
C58 +3V3 0 1uF
C75 +3V3 0 0.1uF
C74 +5V 0 4.7uF
C18 +5V 0 1000uF
R7 NET0213 NET0114 2.2k
R42 +3V3 NET0040 10k
R91 NET0114 0 2.2k
R45 Net-_D35-K_ Net-_D10-A_ 51k
C11 VOUTP 0 47uF
D7 VOUTP Net-_D7-K_ __D7
R52 VOUTN Net-_D35-K_ 249k
R94 Net-_D48-K_ NET0214 470
R38 VOUTN VOUTP 24k
R19 +3V3 Net-_D22-A_ 56
C45 VOUTP VOUTN 0.1uF
R47 0 /NET0135 10k
R23 Net-_D46-K_ Net-_U3-Y_ 1k
R28 +3V3 Net-_D1-A_ 27
C82 5V_switched 0 0.1uF
R82 NET0117 Net-_D38-K_ 1k
R5 0 Net-_D9-K_ 200
C34 5V_switched 0 1uF
C25 +12V 0 1uF
C41 +3V3 0 10uF
C44 +5V 0 10uF
C52 +12V NET0061 22pF
R2 NET0061 +12V 1.8Meg
L1 +5V Net-_D28-A_ 10u
R83 0 NET0061 205k
C40 0 +3V3 0.1uF
C57 0 +3V3 0.1uF
R80 Net-_D49-K_ NET0154 470
R34 Net-_C15-Pad2_ Net-_C42-Pad1_ 75R
R22 Net-_C39-Pad2_ Net-_C42-Pad1_ 75R
C39 NET0046 Net-_C39-Pad2_ 22nF
C79 0 Net-_C79-Pad2_ 0.1uF
R18 Net-_C37-Pad2_ Net-_C42-Pad1_ 75R
R3 Net-_C66-Pad2_ Net-_C42-Pad1_ 75R
C42 Net-_C42-Pad1_ 0 1nF
C37 NET0036 Net-_C37-Pad2_ 22nF
C66 NET0123 Net-_C66-Pad2_ 22nF
C15 NET0137 Net-_C15-Pad2_ 22nF
C29 Net-_U45-OSC1_ 0 18pF
C32 Net-_U45-OSC2_ 0 18pF
C35 Net-_U39-OSC2_ 0 18pF
C4 0 NET0028 0.1uF
C49 NET0028 0 0.1uF
C30 0 5V_switched_CAN 0.1uF
R49 /NET0066 Net-_R49-Pad2_ 120
C62 0 5V_switched_CAN 0.1uF
R12 /NET0010 Net-_R12-Pad2_ 120
C1 0 NET0028 0.1uF
R99 Net-_U45-_RESET_ NET0028 10k
C67 Net-_U39-OSC1_ 0 18pF
R57 Net-_U39-_RESET_ NET0028 10k
C12 NET0028 0 0.1uF
C65 VMOT 0 47uF
C59 VMOT 0 4.7uF
R79 VMOT /NET0104 100k
C61 VMOT 0 0.1uF
R44 Net-_J32-CC2_ 0 5.1k
R56 0 Net-_J32-CC1_ 5.1k
C55 +5V 0 47uF
C23 VMOT 0 47uF
L2 Net-_D41-K_ +5V 100u
C77 +5V 0 47uF
R81 +5V Net-_Q4-G_ 10k
R90 5V_CAN_ENABLE Net-_JP16-A_ 10k
R53 +3V3 Net-_U33-Y_ 10k
R60 +5V Net-_Q15-D_ 10k
R40 Net-_D45-K_ Net-_U2-Y_ 130
R92 NET0070 +3V3 2.2k
R32 +3V3 Net-_U2-Y_ 10k
R24 NET0119 +3V3 2.2k
C73 +3V3 0 0.1uF
C84 +3V3 0 470uF
R11 0 Net-_JP22-B_ 5.1k
R97 NET0016 /NET0067 27
R86 +3V3 NET0193 10k
C72 +3V3 0 0.1uF
R88 NET0096 /NET0015 27
R84 +3V3 NET0144 10k
R93 NET0127 Net-_Q1-G_ 100
R41 NET0059 Net-_Q8-G_ 100
R27 NET0160 Net-_Q11-G_ 100
R51 NET0025 Net-_Q16-G_ 100
R17 +3V3 NET0034 10k
C10 3.3V_PI_OUT 0 0.1uF
R1 3.3V_PI_OUT NET0181 10k
R10 3.3V_PI_OUT NET0018 10k
C5 +5V 0 0.1uF
C3 /NET0177 0 0.1uF
C46 +5V 0 10uF
C50 +5V 0 10uF
R62 VMOT Net-_R62-Pad2_ 50k
R39 Net-_D12-K_ Net-_U33-Y_ 130
R74 NET0091 +3V3 2.2k
R100 Net-_D14-K1_ 0 130
R59 Net-_D14-K2_ NET0188 130
R20 /NET0170 +3V3 2.2k
C24 +3V3 0 0.1uF
R73 /NET0118 0 5.1k
R87 Net-_R62-Pad2_ /NET0118 50k
C85 0 +3V3 1uF
R8 +3V3 /NET0077 10k
R69 Net-_D11-K_ /NET0170 130
R61 +3V3 /NET0170 10k

V_12V +12V 0 DC 12.0
V_3V3 +3V3 0 DC 3.3
V_5V +5V 0 DC 5.0

.control
tran 100u 10m
set filetype=ascii
write cm4-robot_raw.raw all
.endc

.end
