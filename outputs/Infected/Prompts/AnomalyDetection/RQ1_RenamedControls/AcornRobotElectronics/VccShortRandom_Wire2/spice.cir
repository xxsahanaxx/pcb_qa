.title KiCad schematic

.model __D36 D

C26 0 Net-_U8-XTAL1_ 22pF
R57 Net-_U8-_RESET_ NET0164 10k
C84 0 NET0164 0.1uF
C71 0 NET0164 0.1uF
C51 Net-_U8-XTAL2_ 0 22pF
C22 0 Net-_U10-XTAL1_ 22pF
C32 Net-_U10-XTAL2_ 0 22pF
R21 Net-_U10-_RESET_ NET0164 10k
R7 NET0198 NET0164 1k
R22 NET0181 NET0164 1k
R81 /NET0081 NET0148 10k
C63 +3V3 0 0.1uF
R87 0 Net-_U54-SDO/SA1_ 5.1k
C54 Net-_U54-C1_ 0 0.1uF
C75 +3V3 0 1uF
C56 +3V3 0 0.1uF
C12 +5V 0 4.7uF
C81 +5V 0 1000uF
R83 NET0148 NET0002 2.2k
R65 +3V3 NET0041 10k
R66 NET0002 0 2.2k
R41 Net-_D34-K_ Net-_D1-A_ 51k
C57 VOUTP 0 47uF
D36 VOUTP Net-_D36-K_ __D36
R78 VOUTN Net-_D34-K_ 249k
R38 Net-_D7-K_ NET0121 470
R98 VOUTN VOUTP 24k
R9 +3V3 Net-_D4-A_ 56
C42 VOUTP VOUTN 0.1uF
R84 0 /NET0088 10k
R12 Net-_D33-K_ Net-_U46-Y_ 1k
R59 +3V3 Net-_D10-A_ 27
C38 5V_switched 0 0.1uF
R15 NET0073 Net-_D11-K_ 1k
R42 0 Net-_D48-K_ 200
C60 5V_switched 0 1uF
C40 +12V 0 1uF
C85 +3V3 0 10uF
C45 +5V 0 10uF
C8 +12V NET0191 22pF
R14 NET0191 +12V 1.8Meg
L1 +5V Net-_D24-A_ 10u
R75 0 NET0191 205k
C64 0 +3V3 0.1uF
C29 0 +3V3 0.1uF
R11 Net-_D35-K_ NET0138 470
R74 Net-_C39-Pad2_ Net-_C55-Pad1_ 75R
R71 Net-_C46-Pad2_ Net-_C55-Pad1_ 75R
C46 NET0086 Net-_C46-Pad2_ 22nF
C66 0 Net-_C66-Pad2_ 0.1uF
R34 Net-_C3-Pad2_ Net-_C55-Pad1_ 75R
R51 Net-_C69-Pad2_ Net-_C55-Pad1_ 75R
C55 Net-_C55-Pad1_ 0 1nF
C3 NET0092 Net-_C3-Pad2_ 22nF
C69 NET0172 Net-_C69-Pad2_ 22nF
C39 NET0123 Net-_C39-Pad2_ 22nF
C70 Net-_U47-OSC1_ 0 18pF
C5 Net-_U47-OSC2_ 0 18pF
C9 Net-_U38-OSC2_ 0 18pF
C58 0 NET0164 0.1uF
C31 NET0164 0 0.1uF
C50 0 5V_switched_CAN 0.1uF
R27 /NET0109 Net-_R27-Pad2_ 120
C7 0 5V_switched_CAN 0.1uF
R86 /NET0193 Net-_R86-Pad2_ 120
C37 0 NET0164 0.1uF
R69 Net-_U47-_RESET_ NET0164 10k
C41 Net-_U38-OSC1_ 0 18pF
R50 Net-_U38-_RESET_ NET0164 10k
C47 NET0164 0 0.1uF
C18 VMOT 0 47uF
C16 VMOT 0 4.7uF
R43 VMOT /NET0133 100k
C44 VMOT 0 0.1uF
R72 Net-_J18-CC2_ 0 5.1k
R10 0 Net-_J18-CC1_ 5.1k
C17 +5V 0 47uF
C77 VMOT 0 47uF
L3 Net-_D44-K_ +5V 100u
C62 +5V 0 47uF
R25 +5V Net-_Q1-G_ 10k
R56 5V_CAN_ENABLE Net-_JP5-A_ 10k
R82 +3V3 Net-_U24-Y_ 10k
R90 +5V Net-_Q10-D_ 10k
R39 Net-_D43-K_ Net-_U2-Y_ 130
R1 NET0149 +3V3 2.2k
R62 +3V3 Net-_U2-Y_ 10k
R20 NET0102 +3V3 2.2k
C10 +3V3 0 0.1uF
C74 +3V3 0 470uF
R58 0 Net-_JP11-B_ 5.1k
R19 NET0029 /NET0017 27
R60 +3V3 NET0119 10k
C15 +3V3 0 0.1uF
R8 NET0106 /NET0176 27
R55 +3V3 NET0211 10k
R61 NET0097 Net-_Q6-G_ 100
R5 NET0126 Net-_Q16-G_ 100
R18 NET0096 Net-_Q12-G_ 100
R32 NET0060 Net-_Q7-G_ 100
R37 +3V3 NET0171 10k
C72 3.3V_PI_OUT 0 0.1uF
R93 3.3V_PI_OUT NET0174 10k
R6 3.3V_PI_OUT NET0169 10k
C35 +5V 0 0.1uF
C24 /NET0199 0 0.1uF
C76 +5V 0 10uF
C20 +5V 0 10uF
R31 VMOT Net-_R31-Pad2_ 50k
R85 Net-_D38-K_ Net-_U24-Y_ 130
R77 NET0090 +3V3 2.2k
R3 Net-_D16-K1_ 0 130
R73 Net-_D16-K2_ NET0177 130
R4 /NET0084 +3V3 2.2k
C68 +3V3 0 0.1uF
R91 /NET0019 0 5.1k
R47 Net-_R31-Pad2_ /NET0019 50k
C49 0 +3V3 1uF
R70 +3V3 /NET0027 10k
R33 Net-_D14-K_ /NET0084 130
R89 +3V3 /NET0084 10k

V_12V +12V 0 DC 12.0
V_3V3 +3V3 0 DC 3.3
V_5V +5V 0 DC 5.0

.control
tran 100u 10m
set filetype=ascii
write cm4-robot_raw.raw all
.endc

.end
