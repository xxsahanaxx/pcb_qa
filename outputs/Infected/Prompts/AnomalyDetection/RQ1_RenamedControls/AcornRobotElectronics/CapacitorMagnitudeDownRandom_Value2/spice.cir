.title KiCad schematic

.model __D21 D

C12 0 Net-_U42-XTAL1_ 22pF
R80 Net-_U42-_RESET_ NET0199 10k
C77 0 NET0199 0.1uF
C35 0 NET0199 0.1uF
C30 Net-_U42-XTAL2_ 0 22pF
C72 0 Net-_U16-XTAL1_ 22pF
C23 Net-_U16-XTAL2_ 0 22pF
R14 Net-_U16-_RESET_ NET0199 10k
R66 NET0110 NET0199 1k
R3 NET0073 NET0199 1k
R93 /NET0125 NET0197 10k
C64 +3V3 0 0.1uF
R32 0 Net-_U51-SDO/SA1_ 5.1k
C4 Net-_U51-C1_ 0 0.1uF
C52 +3V3 0 0.1uF
C67 +3V3 0 1uF
C61 +5V 0 4.7uF
C7 +5V 0 1000uF
R26 NET0197 NET0003 2.2k
R21 +3V3 NET0211 10k
R54 NET0003 0 2.2k
R69 Net-_D9-K_ Net-_D36-A_ 51k
C62 VOUTP 0 47uF
D21 VOUTP Net-_D21-K_ __D21
R85 VOUTN Net-_D9-K_ 249k
R101 Net-_D46-K_ NET0214 470
R49 VOUTN VOUTP 24k
R19 +3V3 Net-_D33-A_ 56
C13 VOUTP VOUTN 0.1uF
R46 0 /NET0062 10k
R5 Net-_D20-K_ Net-_U12-Y_ 1k
R91 +3V3 Net-_D14-A_ 27
C10 5V_switched 0 0.1uF
R51 NET0007 Net-_D25-K_ 1k
R27 0 Net-_D34-K_ 200
C55 5V_switched 0 1uF
C58 +12V 0 1uF
C34 +3V3 0 10uF
C56 +5V 0 10uF
C3 +12V NET0118 22pF
R22 NET0118 +12V 1.8Meg
L3 +5V Net-_D19-A_ 10u
R41 0 NET0118 205k
C33 0 +3V3 0.1uF
C79 0 +3V3 0.1uF
R34 Net-_D49-K_ NET0067 470
R48 Net-_C9-Pad2_ Net-_C71-Pad1_ 75R
R10 Net-_C78-Pad2_ Net-_C71-Pad1_ 75R
C78 NET0074 Net-_C78-Pad2_ 22nF
C60 0 Net-_C60-Pad2_ 0.1uF
R28 Net-_C74-Pad2_ Net-_C71-Pad1_ 75R
R15 Net-_C66-Pad2_ Net-_C71-Pad1_ 75R
C71 Net-_C71-Pad1_ 0 1nF
C74 NET0200 Net-_C74-Pad2_ 22nF
C66 NET0096 Net-_C66-Pad2_ 22nF
C9 NET0140 Net-_C9-Pad2_ 22nF
C22 Net-_U22-OSC1_ 0 18pF
C75 Net-_U22-OSC2_ 0 18pF
C24 Net-_U33-OSC2_ 0 18pF
C5 0 NET0199 0.1uF
C54 NET0199 0 0.1uF
C40 0 5V_switched_CAN 0.1uF
R95 /NET0209 Net-_R95-Pad2_ 120
C28 0 5V_switched_CAN 0.1uF
R9 /NET0208 Net-_R9-Pad2_ 120
C47 0 NET0199 0.1uF
R88 Net-_U22-_RESET_ NET0199 10k
C57 Net-_U33-OSC1_ 0 18pF
R4 Net-_U33-_RESET_ NET0199 10k
C84 NET0199 0 0.1uF
C14 VMOT 0 47uF
C38 VMOT 0 4.7uF
R56 VMOT /NET0108 100k
C86 VMOT 0 0.1uF
R76 Net-_J5-CC2_ 0 5.1k
R83 0 Net-_J5-CC1_ 5.1k
C21 +5V 0 47uF
C44 VMOT 0 47uF
L2 Net-_D23-K_ +5V 100u
C1 +5V 0 47uF
R7 +5V Net-_Q7-G_ 10k
R35 5V_CAN_ENABLE Net-_JP21-A_ 10k
R92 +3V3 Net-_U5-A_ 10k
R52 +5V Net-_Q13-G_ 10k
R63 Net-_D10-K_ Net-_U23-Y_ 130
R75 NET0079 +3V3 2.2k
R38 +3V3 Net-_U23-Y_ 10k
R23 NET0006 +3V3 2.2k
C81 +3V3 0 0.1uF
C48 +3V3 0 470uF
R82 0 Net-_JP7-B_ 5.1k
R89 NET0212 /NET0081 27
R99 +3V3 NET0085 10k
C37 +3V3 0 0.1uF
R96 NET0082 /NET0117 27
R98 +3V3 NET0091 10k
R39 NET0034 Net-_Q15-G_ 100
R65 NET0030 Net-_Q9-G_ 100
R44 NET0037 Net-_Q16-G_ 100
R24 NET0145 Net-_Q1-G_ 100
R78 +3V3 NET0130 10k
C46 3.3V_PI_OUT 0 0.1uF
R79 3.3V_PI_OUT NET0014 10k
R25 3.3V_PI_OUT NET0101 10k
C16 +5V 0 0.1uF
C53 /NET0143 0 0.1uF
C25 +5V 0 10uF
C20 +5V 0 10uF
R30 VMOT Net-_R30-Pad2_ 50k
R74 Net-_D12-K_ Net-_U5-A_ 130
R72 NET0068 +3V3 2.2k
R57 Net-_D37-K1_ 0 130
R64 Net-_D37-K2_ NET0170 130
R73 /NET0042 +3V3 2.2k
C85 +3V3 0 0.1uF
R20 /NET0060 0 5.1k
R37 Net-_R30-Pad2_ /NET0060 50k
C2 0 +3V3 1uF
R70 +3V3 /NET0159 10k
R60 Net-_D39-K_ /NET0042 130
R29 +3V3 /NET0042 10k

V_12V +12V 0 DC 12.0
V_3V3 +3V3 0 DC 3.3
V_5V +5V 0 DC 5.0

.control
tran 100u 10m
set filetype=ascii
write cm4-robot_raw.raw all
.endc

.end
