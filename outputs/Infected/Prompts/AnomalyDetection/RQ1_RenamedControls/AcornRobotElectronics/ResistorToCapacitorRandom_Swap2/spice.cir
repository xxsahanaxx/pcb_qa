.title KiCad schematic

.model __D31 D

C62 0 Net-_U3-XTAL1_ 22pF
R9 Net-_U3-_RESET_ NET0085 10k
C7 0 NET0085 0.1uF
C77 0 NET0085 0.1uF
C11 Net-_U3-XTAL2_ 0 22pF
C66 0 Net-_U2-XTAL1_ 22pF
C79 Net-_U2-XTAL2_ 0 22pF
R77 Net-_U2-_RESET_ NET0085 10k
R26 NET0016 NET0085 1k
R25 NET0157 NET0085 1k
R95 /NET0093 NET0068 10k
C49 +3V3 0 0.1uF
R60 0 Net-_U57-SDO/SA1_ 5.1k
C30 Net-_U57-C1_ 0 0.1uF
C3 +3V3 0 1uF
C35 +3V3 0 0.1uF
C69 +5V 0 4.7uF
C31 +5V 0 1000uF
R23 NET0068 NET0119 2.2k
R58 +3V3 NET0195 10k
R31 NET0119 0 2.2k
R14 Net-_D17-K_ Net-_D27-A_ 51k
C45 VOUTP 0 47uF
D31 VOUTP Net-_D31-K_ __D31
R32 VOUTN Net-_D17-K_ 249k
R33 Net-_D26-K_ NET0140 470
R71 VOUTN VOUTP 24k
R45 +3V3 Net-_D16-A_ 56
C70 VOUTP VOUTN 0.1uF
R3 0 /NET0175 10k
R15 Net-_D12-K_ Net-_U28-Y_ 1k
R12 +3V3 Net-_D47-A_ 27
C54 5V_switched 0 0.1uF
R76 NET0056 Net-_D38-K_ 1k
R72 0 Net-_D21-K_ 200
C5 5V_switched 0 1uF
C25 +12V 0 1uF
C84 +3V3 0 10uF
C60 +5V 0 10uF
C32 +12V NET0194 22pF
R89 NET0194 +12V 1.8Meg
L1 +5V Net-_D34-A_ 10u
R50 0 NET0194 205k
C80 0 +3V3 0.1uF
C64 0 +3V3 0.1uF
R81 Net-_D29-K_ NET0124 470
R29 Net-_C24-Pad2_ Net-_C63-Pad1_ 75R
R49 Net-_C73-Pad2_ Net-_C63-Pad1_ 75R
C73 NET0117 Net-_C73-Pad2_ 22nF
C6 0 Net-_C6-Pad2_ 0.1uF
R24 Net-_C40-Pad2_ Net-_C63-Pad1_ 75R
R57 Net-_C81-Pad2_ Net-_C63-Pad1_ 75R
C63 Net-_C63-Pad1_ 0 1nF
C40 NET0052 Net-_C40-Pad2_ 22nF
C81 NET0088 Net-_C81-Pad2_ 22nF
C24 NET0187 Net-_C24-Pad2_ 22nF
C20 Net-_U25-OSC1_ 0 18pF
C48 Net-_U25-OSC2_ 0 18pF
C19 Net-_U10-OSC2_ 0 18pF
C58 0 NET0085 0.1uF
C10 NET0085 0 0.1uF
C83 0 5V_switched_CAN 0.1uF
R28 /NET0075 Net-_R28-Pad2_ 120
C85 0 5V_switched_CAN 0.1uF
R83 /NET0078 Net-_R83-Pad2_ 120
C16 0 NET0085 0.1uF
R59 Net-_U25-_RESET_ NET0085 10k
C13 Net-_U10-OSC1_ 0 18pF
R98 Net-_U10-_RESET_ NET0085 10k
C78 NET0085 0 0.1uF
C18 VMOT 0 47uF
C17 VMOT 0 4.7uF
R90 VMOT /NET0130 100k
C37 VMOT 0 0.1uF
R66 Net-_J37-CC2_ 0 5.1k
R20 0 Net-_J37-CC1_ 5.1k
C65 +5V 0 47uF
C15 VMOT 0 47uF
L3 Net-_D33-K_ +5V 100u
C39 +5V 0 47uF
R51 +5V Net-_Q2-G_ 10k
R91 5V_CAN_ENABLE Net-_JP8-A_ 10k
R52 +3V3 Net-_U18-A_ 10k
R1 +5V Net-_Q15-G_ 10k
R27 Net-_D20-K_ Net-_U16-Y_ 130
R37 NET0008 +3V3 2.2k
R67 +3V3 Net-_U16-Y_ 10k
R82 NET0166 +3V3 2.2k
C21 +3V3 0 0.1uF
C76 +3V3 0 470uF
R97 0 Net-_JP21-B_ 5.1k
C8 3.3V_PI_OUT 0 0.1uF
R86 3.3V_PI_OUT NET0172 10k
R100 3.3V_PI_OUT NET0096 10k
R7 NET0149 /NET0101 27
R8 +3V3 NET0045 10k
C51 +3V3 0 0.1uF
R10 NET0042 /NET0066 27
R36 +3V3 NET0191 10k
R35 +3V3 NET0098 10k
R101 NET0114 Net-_Q9-G_ 100
R78 NET0067 Net-_Q14-G_ 100
R5 NET0021 Net-_Q3-G_ 100
R40 NET0180 Net-_Q7-G_ 100
C59 +5V 0 0.1uF
C50 /NET0170 0 0.1uF
C47 +5V 0 10uF
C33 +5V 0 10uF
R44 VMOT Net-_R44-Pad2_ 50k
R102 Net-_D7-K_ Net-_U18-A_ 130
R4 NET0116 +3V3 2.2k
R55 Net-_D45-K1_ 0 130
R34 Net-_D45-K2_ NET0102 130
R39 /NET0211 +3V3 2.2k
C44 +3V3 0 0.1uF
R75 /NET0100 0 5.1k
R46 Net-_R44-Pad2_ /NET0100 50k
C75 0 +3V3 1uF
R94 +3V3 /NET0118 10k
R84 Net-_D44-K_ /NET0211 130
R38 +3V3 /NET0211 10k

V_12V +12V 0 DC 12.0
V_3V3 +3V3 0 DC 3.3
V_5V +5V 0 DC 5.0

.control
tran 100u 10m
set filetype=ascii
write cm4-robot_raw.raw all
.endc

.end
