.title KiCad schematic

.model __D15 D

C2 0 Net-_U2-XTAL1_ 22pF
R70 Net-_U2-_RESET_ NET0054 10k
C27 0 NET0054 0.1uF
C22 0 NET0054 0.1uF
C39 Net-_U2-XTAL2_ 0 22pF
C13 0 Net-_U34-XTAL1_ 22pF
C53 Net-_U34-XTAL2_ 0 22pF
R59 Net-_U34-_RESET_ NET0054 10k
R99 NET0141 NET0054 1k
R4 NET0074 NET0054 1k
R57 /NET0101 NET0192 10k
C26 +3V3 0 0.1uF
R16 0 Net-_U29-SDO/SA1_ 5.1k
C63 Net-_U29-C1_ 0 0.1uF
C54 +3V3 0 1uF
C30 +3V3 0 0.1uF
C58 +5V 0 4.7uF
C78 +5V 0 1000uF
R55 NET0192 NET0052 2.2k
R65 +3V3 NET0124 10k
R13 NET0052 0 2.2k
R37 Net-_D41-K_ Net-_D40-A_ 51k
C31 VOUTP 0 47uF
D15 VOUTP Net-_D15-K_ __D15
R20 VOUTN Net-_D41-K_ 249k
R29 Net-_D20-K_ NET0111 470
R18 VOUTN VOUTP 24k
R87 +3V3 Net-_D1-A_ 56
C40 VOUTP VOUTN 0.1uF
R41 0 /NET0182 10k
R66 Net-_D4-K_ Net-_U9-Y_ 1k
R62 +3V3 Net-_D14-A_ 27
C14 5V_switched 0 0.1uF
R25 NET0133 Net-_D33-K_ 1k
R63 0 Net-_D3-K_ 200
C73 5V_switched 0 1uF
C72 +12V 0 1uF
C33 +3V3 0 10uF
C21 +5V 0 10uF
C80 +12V NET0089 22pF
R88 NET0089 +12V 1.8Meg
L1 +5V Net-_D18-A_ 10u
R35 0 NET0089 205k
C79 0 +3V3 0.1uF
C68 0 +3V3 0.1uF
R60 Net-_D5-K_ NET0214 470
R80 Net-_C23-Pad2_ Net-_C55-Pad1_ 75R
R56 Net-_C6-Pad2_ Net-_C55-Pad1_ 75R
C6 NET0120 Net-_C6-Pad2_ 22nF
C69 0 Net-_C69-Pad2_ 0.1uF
R52 Net-_C64-Pad2_ Net-_C55-Pad1_ 75R
R9 Net-_C15-Pad2_ Net-_C55-Pad1_ 75R
C55 Net-_C55-Pad1_ 0 1nF
C64 NET0154 Net-_C64-Pad2_ 22nF
C15 NET0121 Net-_C15-Pad2_ 22nF
C23 NET0099 Net-_C23-Pad2_ 22nF
C9 Net-_U24-OSC1_ 0 18pF
C83 Net-_U24-OSC2_ 0 18pF
C84 Net-_U45-OSC2_ 0 18pF
C24 0 NET0054 0.1uF
C17 NET0054 0 0.1uF
C51 0 5V_switched_CAN 0.1uF
R77 /NET0005 Net-_R77-Pad2_ 120
C74 0 5V_switched_CAN 0.1uF
R2 /NET0118 Net-_R2-Pad2_ 120
C43 0 NET0054 0.1uF
R1 Net-_U24-_RESET_ NET0054 10k
C34 Net-_U45-OSC1_ 0 18pF
R47 Net-_U45-_RESET_ NET0054 10k
C36 NET0054 0 0.1uF
C81 VMOT 0 47uF
C59 VMOT 0 4.7uF
R86 VMOT /NET0015 100k
C5 VMOT 0 0.1uF
R75 Net-_J15-CC2_ 0 5.1k
R95 0 Net-_J15-CC1_ 5.1k
C11 +5V 0 47uF
C56 VMOT 0 47uF
L3 Net-_D43-K_ +5V 100u
C77 +5V 0 47uF
R78 +5V Net-_Q6-G_ 10k
R102 5V_CAN_ENABLE Net-_JP20-A_ 10k
R45 +3V3 Net-_U36-Y_ 10k
R15 +5V Net-_Q14-D_ 10k
R5 Net-_D19-K_ Net-_U36-A_ 130
R85 NET0004 +3V3 2.2k
R50 +3V3 Net-_U36-A_ 10k
R27 NET0127 +3V3 2.2k
C28 +3V3 0 0.1uF
C86 +3V3 0 470uF
R8 0 Net-_JP2-B_ 5.1k
R40 NET0062 /NET0034 27
R30 +3V3 NET0172 10k
C35 +3V3 0 0.1uF
R28 NET0039 /NET0048 27
R22 +3V3 NET0178 10k
R32 NET0036 Net-_Q15-G_ 100
R11 NET0041 Net-_Q8-G_ 100
R6 NET0079 Net-_Q16-G_ 100
R92 NET0156 Net-_Q7-G_ 100
R31 +3V3 NET0158 10k
C4 3.3V_PI_OUT 0 0.1uF
R24 3.3V_PI_OUT NET0019 10k
R39 3.3V_PI_OUT NET0212 10k
C38 +5V 0 0.1uF
C44 /NET0104 0 0.1uF
C60 +5V 0 10uF
C48 +5V 0 10uF
R73 VMOT Net-_R46-Pad1_ 50k
R7 Net-_D29-K_ Net-_U36-Y_ 130
R91 NET0012 +3V3 2.2k
R44 Net-_D27-K1_ 0 130
R43 Net-_D27-K2_ NET0132 130
R38 /NET0042 +3V3 2.2k
C57 +3V3 0 0.1uF
R36 /NET0018 0 5.1k
R46 Net-_R46-Pad1_ /NET0018 50k
C12 0 +3V3 1uF
R42 +3V3 /NET0119 10k
R10 Net-_D22-K_ /NET0042 130
R74 +3V3 /NET0042 10k

V_12V +12V 0 DC 12.0
V_3V3 +3V3 0 DC 3.3
V_5V +5V 0 DC 5.0

.control
tran 100u 10m
set filetype=ascii
write cm4-robot_raw.raw all
.endc

.end
