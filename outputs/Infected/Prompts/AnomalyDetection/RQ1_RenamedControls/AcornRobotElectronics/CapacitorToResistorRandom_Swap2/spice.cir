.title KiCad schematic

.model __D29 D

C14 0 Net-_U19-XTAL1_ 22pF
R72 Net-_U19-_RESET_ NET0090 10k
C44 0 NET0090 0.1uF
C60 0 NET0090 0.1uF
C33 Net-_U19-XTAL2_ 0 22pF
C36 0 Net-_U16-XTAL1_ 22pF
C84 Net-_U16-XTAL2_ 0 22pF
R79 Net-_U16-_RESET_ NET0090 10k
R17 NET0034 NET0090 1k
R94 NET0089 NET0090 1k
R81 /NET0035 NET0043 10k
C76 +3V3 0 0.1uF
R83 0 Net-_U10-SDO/SA1_ 5.1k
C66 Net-_U10-C1_ 0 0.1uF
C11 +3V3 0 1uF
C40 +3V3 0 0.1uF
C64 +5V 0 4.7uF
C30 +5V 0 1000uF
R92 NET0043 NET0152 2.2k
R8 NET0152 0 2.2k
R40 +3V3 NET0133 10k
R4 0 Net-_J12-CC1_ 5.1k
R10 Net-_D1-K_ Net-_D49-A_ 51k
C18 VOUTP 0 47uF
D29 VOUTP Net-_D29-K_ __D29
R1 VOUTN Net-_D1-K_ 249k
R89 Net-_D22-K_ NET0093 470
R100 VOUTN VOUTP 24k
R21 +3V3 Net-_D26-A_ 56
C5 VOUTP VOUTN 0.1uF
R38 0 /NET0037 10k
R53 Net-_D24-K_ Net-_U12-Y_ 1k
R71 +3V3 Net-_D48-A_ 27
C82 5V_switched 0 0.1uF
R93 NET0123 Net-_D19-K_ 1k
R55 0 Net-_D3-K_ 200
C28 5V_switched 0 1uF
C73 +12V 0 1uF
C61 +3V3 0 10uF
C54 +5V 0 10uF
C56 +12V NET0170 22pF
R102 NET0170 +12V 1.8Meg
L1 +5V Net-_D28-A_ 10u
R29 0 NET0170 205k
C34 0 +3V3 0.1uF
C71 0 +3V3 0.1uF
R34 Net-_D43-K_ NET0086 470
R76 Net-_C9-Pad2_ Net-_C32-Pad1_ 75R
R41 Net-_C68-Pad2_ Net-_C32-Pad1_ 75R
C68 NET0070 Net-_C68-Pad2_ 22nF
C1 0 Net-_C1-Pad2_ 0.1uF
R33 Net-_C6-Pad2_ Net-_C32-Pad1_ 75R
R26 Net-_C67-Pad2_ Net-_C32-Pad1_ 75R
C32 Net-_C32-Pad1_ 0 1nF
C6 NET0068 Net-_C6-Pad2_ 22nF
C67 NET0120 Net-_C67-Pad2_ 22nF
C9 NET0200 Net-_C9-Pad2_ 22nF
C42 Net-_U42-OSC1_ 0 18pF
C58 Net-_U42-OSC2_ 0 18pF
C57 Net-_U24-OSC2_ 0 18pF
C19 0 NET0090 0.1uF
C83 NET0090 0 0.1uF
C75 0 5V_switched_CAN 0.1uF
R19 /NET0197 Net-_R19-Pad2_ 120
C52 0 5V_switched_CAN 0.1uF
R30 /NET0103 Net-_R30-Pad2_ 120
C47 0 NET0090 0.1uF
R99 Net-_U42-_RESET_ NET0090 10k
C53 Net-_U24-OSC1_ 0 18pF
R22 Net-_U24-_RESET_ NET0090 10k
C81 NET0090 0 0.1uF
C10 VMOT 0 47uF
C8 VMOT 0 4.7uF
R37 VMOT /NET0088 100k
C24 VMOT 0 0.1uF
R57 Net-_J12-CC2_ 0 5.1k
C72 +5V 0 47uF
C48 VMOT 0 47uF
L3 Net-_D10-K_ +5V 100u
C74 +5V 0 47uF
R101 +5V Net-_Q8-G_ 10k
R61 5V_CAN_ENABLE Net-_JP18-A_ 10k
R47 +3V3 Net-_U13-A_ 10k
R9 +5V Net-_Q12-G_ 10k
R90 Net-_D36-K_ Net-_U50-A_ 130
R36 NET0040 +3V3 2.2k
R18 +3V3 Net-_U50-A_ 10k
R25 NET0173 +3V3 2.2k
C85 +3V3 0 0.1uF
C46 +3V3 0 470uF
R6 0 Net-_JP4-B_ 5.1k
C80 3.3V_PI_OUT 0 0.1uF
R87 3.3V_PI_OUT NET0136 10k
R62 3.3V_PI_OUT NET0075 10k
R27 NET0107 /NET0175 27
R31 +3V3 NET0062 10k
C12 +3V3 0 0.1uF
R35 NET0053 /NET0051 27
R95 +3V3 NET0139 10k
R59 +3V3 NET0061 10k
R3 NET0029 Net-_Q11-G_ 100
R63 NET0104 Net-_Q16-G_ 100
R60 NET0058 Net-_Q5-G_ 100
R97 NET0110 Net-_Q7-G_ 100
C25 +5V 0 0.1uF
C41 /NET0193 0 0.1uF
C55 +5V 0 10uF
C49 +5V 0 10uF
R56 VMOT Net-_R2-Pad1_ 50k
R46 Net-_D17-K_ Net-_U13-A_ 130
R98 NET0188 +3V3 2.2k
R64 Net-_D40-K1_ 0 130
R39 Net-_D40-K2_ NET0121 130
R11 /NET0154 +3V3 2.2k
C7 +3V3 0 0.1uF
R12 /NET0082 0 5.1k
R2 Net-_R2-Pad1_ /NET0082 50k
C29 0 +3V3 1uF
R86 +3V3 /NET0119 10k
R80 Net-_D16-K_ /NET0154 130
R13 +3V3 /NET0154 10k

V_12V +12V 0 DC 12.0
V_3V3 +3V3 0 DC 3.3
V_5V +5V 0 DC 5.0

.control
tran 100u 10m
set filetype=ascii
write cm4-robot_raw.raw all
.endc

.end
