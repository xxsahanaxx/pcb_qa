.title KiCad schematic

.model __D18 D

C44 0 Net-_U53-XTAL1_ 22pF
R46 Net-_U53-_RESET_ NET0073 10k
C9 0 NET0073 0.1uF
C24 0 NET0073 0.1uF
C86 Net-_U53-XTAL2_ 0 22pF
C42 0 Net-_U17-XTAL1_ 22pF
C43 Net-_U17-XTAL2_ 0 22pF
R70 Net-_U17-_RESET_ NET0073 10k
R37 NET0094 NET0073 1k
R47 NET0021 NET0073 1k
R58 /NET0194 NET0207 10k
C81 +3V3 0 0.1uF
R1 0 Net-_U44-SDO/SA1_ 5.1k
C79 Net-_U44-C1_ 0 0.1uF
C63 +3V3 0 1uF
C74 +3V3 0 0.1uF
C20 +5V 0 4.7uF
C19 +5V 0 1000uF
R50 NET0207 NET0025 2.2k
R9 +3V3 NET0106 10k
R39 NET0025 0 2.2k
R56 Net-_D17-K_ Net-_D40-A_ 51k
C51 VOUTP 0 47uF
D18 VOUTP Net-_D18-K_ __D18
R51 VOUTN Net-_D17-K_ 249k
R63 Net-_D42-K_ NET0028 470
R93 VOUTN VOUTP 24k
R42 +3V3 Net-_D26-A_ 56
C37 VOUTP VOUTN 0.1uF
R61 0 /NET0138 10k
R32 Net-_D31-K_ Net-_U15-Y_ 1k
R26 +3V3 Net-_D3-A_ 27
C21 5V_switched 0 0.1uF
R45 NET0166 Net-_D29-K_ 1k
R30 0 Net-_D19-K_ 200
C31 5V_switched 0 1uF
C25 +12V 0 1uF
C18 +3V3 0 10uF
C58 +5V 0 10uF
C12 +12V NET0018 22pF
R96 NET0018 +12V 1.8Meg
L1 +5V Net-_D38-A_ 10u
R80 0 NET0018 205k
C49 0 +3V3 0.1uF
C36 0 +3V3 0.1uF
R66 Net-_D24-K_ NET0160 470
R76 Net-_C60-Pad2_ Net-_C30-Pad1_ 75R
R38 Net-_C70-Pad2_ Net-_C30-Pad1_ 75R
C70 NET0144 Net-_C70-Pad2_ 22nF
C84 0 Net-_C84-Pad2_ 0.1uF
R21 Net-_C35-Pad2_ Net-_C30-Pad1_ 75R
R10 Net-_C33-Pad2_ Net-_C30-Pad1_ 75R
C30 Net-_C30-Pad1_ 0 1nF
C35 NET0118 Net-_C35-Pad2_ 22nF
C33 NET0169 Net-_C33-Pad2_ 22nF
C60 NET0095 Net-_C60-Pad2_ 22nF
C66 Net-_U35-OSC1_ 0 18pF
C45 Net-_U35-OSC2_ 0 18pF
C16 Net-_U6-OSC2_ 0 18pF
C40 0 NET0073 0.1uF
C76 NET0073 0 0.1uF
C27 0 5V_switched_CAN 0.1uF
R2 /NET0099 Net-_R2-Pad2_ 120
C11 0 5V_switched_CAN 0.1uF
R23 /NET0042 Net-_R23-Pad2_ 120
C65 0 NET0073 0.1uF
R55 Net-_U35-_RESET_ NET0073 10k
C57 Net-_U6-OSC1_ 0 18pF
R97 Net-_U6-_RESET_ NET0073 10k
C48 NET0073 0 0.1uF
C64 VMOT 0 47uF
C26 VMOT 0 4.7uF
R22 VMOT /NET0001 100k
C61 VMOT 0 0.1uF
R17 Net-_J10-CC2_ 0 5.1k
R65 0 Net-_J10-CC1_ 5.1k
C41 +5V 0 47uF
C55 VMOT 0 47uF
L2 Net-_D28-K_ +5V 100u
C4 +5V 0 47uF
R7 +5V Net-_Q15-G_ 10k
R83 5V_CAN_ENABLE Net-_JP21-A_ 10k
R64 +3V3 Net-_U54-A_ 10k
R12 +5V Net-_Q11-D_ 10k
R34 Net-_D9-K_ Net-_U52-Y_ 130
R18 NET0030 +3V3 2.2k
R6 +3V3 Net-_U52-Y_ 10k
R31 NET0048 +3V3 2.2k
C13 +3V3 0 0.1uF
C71 +3V3 0 470uF
R29 0 Net-_JP7-B_ 5.1k
C56 3.3V_PI_OUT 0 0.1uF
R74 3.3V_PI_OUT NET0202 10k
R89 3.3V_PI_OUT NET0008 10k
R84 NET0189 /NET0157 27
R62 +3V3 NET0064 10k
C72 +3V3 0 0.1uF
R35 NET0113 /NET0041 27
R20 +3V3 NET0147 10k
R73 +3V3 NET0078 10k
R78 NET0026 Net-_Q3-G_ 100
R88 NET0032 Net-_Q8-G_ 100
R44 NET0199 Net-_Q4-G_ 100
R11 NET0097 Net-_Q5-G_ 100
C47 +5V 0 0.1uF
C82 /NET0104 0 0.1uF
C52 +5V 0 10uF
C14 +5V 0 10uF
R40 VMOT Net-_R40-Pad2_ 50k
R87 Net-_D35-K_ Net-_U54-A_ 130
R15 NET0013 +3V3 2.2k
R41 Net-_D37-K1_ 0 130
R75 Net-_D37-K2_ NET0074 130
R3 /NET0150 +3V3 2.2k
C38 +3V3 0 0.1uF
R102 /NET0033 0 5.1k
R43 Net-_R40-Pad2_ /NET0033 50k
C75 0 +3V3 1uF
R77 +3V3 /NET0143 10k
R67 Net-_D44-K_ /NET0150 130
R101 +3V3 /NET0150 10k

V_12V +12V 0 DC 12.0
V_3V3 +3V3 0 DC 3.3
V_5V +5V 0 DC 5.0

.control
tran 100u 10m
set filetype=ascii
write cm4-robot_raw.raw all
.endc

.end
