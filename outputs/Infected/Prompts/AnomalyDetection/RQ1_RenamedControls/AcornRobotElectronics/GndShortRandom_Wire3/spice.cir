.title KiCad schematic

.model __D32 D

C12 0 Net-_U2-XTAL1_ 22pF
R83 Net-_U2-_RESET_ NET0058 10k
C45 0 NET0058 0.1uF
C29 0 NET0058 0.1uF
C78 Net-_U2-XTAL2_ 0 22pF
C75 0 Net-_U30-XTAL1_ 22pF
C51 Net-_U30-XTAL2_ 0 22pF
R82 Net-_U30-_RESET_ NET0058 10k
R32 NET0175 NET0058 1k
R31 NET0027 NET0058 1k
R86 /NET0127 NET0031 10k
C33 +3V3 0 0.1uF
R62 0 Net-_U41-SDO/SA1_ 5.1k
C39 Net-_U41-C1_ 0 0.1uF
C56 +3V3 0 1uF
C21 +3V3 0 0.1uF
C74 +5V 0 4.7uF
C84 +5V 0 1000uF
R37 NET0031 NET0092 2.2k
R93 +3V3 NET0011 10k
R20 NET0092 0 2.2k
R8 Net-_D16-K_ Net-_D2-A_ 51k
C36 VOUTP 0 47uF
D32 VOUTP Net-_D32-K_ __D32
R71 VOUTN Net-_D16-K_ 249k
R14 Net-_D33-K_ NET0122 470
R90 VOUTN VOUTP 24k
R85 +3V3 Net-_D21-A_ 56
C79 VOUTP VOUTN 0.1uF
R92 0 /NET0178 10k
R7 Net-_D17-K_ Net-_U23-Y_ 1k
R70 +3V3 Net-_D4-A_ 27
C15 5V_switched 0 0.1uF
R30 NET0142 Net-_D42-K_ 1k
R47 0 Net-_D39-K_ 200
C20 5V_switched 0 1uF
C1 +12V 0 1uF
C68 +3V3 0 10uF
C82 +5V 0 10uF
C22 +12V NET0196 22pF
R84 NET0196 +12V 1.8Meg
L3 +5V Net-_D49-A_ 10u
R35 0 NET0196 205k
C38 0 +3V3 0.1uF
C81 0 +3V3 0.1uF
R101 Net-_D25-K_ NET0094 470
R21 Net-_C17-Pad2_ Net-_C69-Pad1_ 75R
R36 Net-_C43-Pad2_ Net-_C69-Pad1_ 75R
C43 NET0057 Net-_C43-Pad2_ 22nF
C2 0 Net-_C2-Pad2_ 0.1uF
R23 Net-_C24-Pad2_ Net-_C69-Pad1_ 75R
R91 Net-_C32-Pad2_ Net-_C69-Pad1_ 75R
C69 Net-_C69-Pad1_ 0 1nF
C24 NET0211 Net-_C24-Pad2_ 22nF
C32 NET0139 Net-_C32-Pad2_ 22nF
C17 NET0214 Net-_C17-Pad2_ 22nF
C30 Net-_U27-OSC1_ 0 18pF
C41 Net-_U27-OSC2_ 0 18pF
C25 Net-_U33-OSC2_ 0 18pF
C59 0 NET0058 0.1uF
C34 NET0058 0 0.1uF
C73 0 5V_switched_CAN 0.1uF
R40 /NET0164 Net-_R40-Pad2_ 120
C4 0 5V_switched_CAN 0.1uF
R54 /NET0185 Net-_R54-Pad2_ 120
C6 0 NET0058 0.1uF
R52 Net-_U27-_RESET_ NET0058 10k
C55 Net-_U33-OSC1_ 0 18pF
R96 Net-_U33-_RESET_ NET0058 10k
C40 NET0058 0 0.1uF
C80 VMOT 0 47uF
C53 VMOT 0 4.7uF
R38 VMOT /NET0044 100k
C14 VMOT 0 0.1uF
R33 Net-_J27-CC2_ 0 5.1k
R18 0 Net-_J27-CC1_ 5.1k
C3 +5V 0 47uF
C60 VMOT 0 47uF
L2 Net-_D12-K_ +5V 100u
C65 +5V 0 47uF
R65 +5V Net-_Q5-G_ 10k
R51 5V_CAN_ENABLE Net-_JP20-A_ 10k
R45 +3V3 Net-_U29-Y_ 10k
R9 +5V Net-_Q14-D_ 10k
R64 Net-_D1-K_ Net-_U29-A_ 130
R79 NET0183 +3V3 2.2k
R80 +3V3 Net-_U29-A_ 10k
R24 NET0109 +3V3 2.2k
C31 +3V3 0 0.1uF
C63 +3V3 0 470uF
R4 0 Net-_JP21-B_ 5.1k
R94 NET0088 /NET0157 27
R29 +3V3 NET0180 10k
C52 +3V3 0 0.1uF
R12 NET0210 /NET0017 27
R3 +3V3 NET0200 10k
R60 NET0148 Net-_Q4-G_ 100
R41 NET0120 Net-_Q16-G_ 100
R98 NET0051 Net-_Q13-G_ 100
R100 NET0100 Net-_Q6-G_ 100
R72 +3V3 NET0195 10k
C72 3.3V_PI_OUT 0 0.1uF
R87 3.3V_PI_OUT NET0036 10k
R34 3.3V_PI_OUT NET0129 10k
C44 +5V 0 0.1uF
C47 /NET0035 0 0.1uF
C48 +5V 0 10uF
C7 +5V 0 10uF
R42 VMOT Net-_R42-Pad2_ 50k
R5 Net-_D47-K_ Net-_U29-Y_ 130
R69 NET0081 +3V3 2.2k
R43 Net-_D20-K1_ 0 130
R11 Net-_D20-K2_ NET0144 130
R28 /NET0130 +3V3 2.2k
C42 +3V3 0 0.1uF
R88 /NET0134 0 5.1k
R66 Net-_R42-Pad2_ /NET0134 50k
C11 0 +3V3 1uF
R97 +3V3 /NET0020 10k
R25 Net-_D19-K_ /NET0130 130
R73 +3V3 /NET0130 10k

V_12V +12V 0 DC 12.0
V_3V3 +3V3 0 DC 3.3
V_5V +5V 0 DC 5.0

.control
tran 100u 10m
set filetype=ascii
write cm4-robot_raw.raw all
.endc

.end
