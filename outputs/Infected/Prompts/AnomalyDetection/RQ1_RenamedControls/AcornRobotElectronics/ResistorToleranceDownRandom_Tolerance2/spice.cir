.title KiCad schematic

.model __D11 D

C41 0 Net-_U42-XTAL1_ 22pF
R14 Net-_U42-_RESET_ NET0131 10k
C51 0 NET0131 0.1uF
C49 0 NET0131 0.1uF
C81 Net-_U42-XTAL2_ 0 22pF
C47 0 Net-_U10-XTAL1_ 22pF
C86 Net-_U10-XTAL2_ 0 22pF
R29 Net-_U10-_RESET_ NET0131 10k
R18 NET0079 NET0131 1k
R85 NET0087 NET0131 1k
R53 /NET0016 NET0110 10k
C59 +3V3 0 0.1uF
R70 0 Net-_U48-SDO/SA1_ 5.1k
C75 Net-_U48-C1_ 0 0.1uF
C20 +3V3 0 1uF
C56 +3V3 0 0.1uF
C53 +5V 0 4.7uF
C28 +5V 0 1000uF
R92 NET0110 NET0042 2.2k
R83 +3V3 NET0001 10k
R35 NET0042 0 2.2k
R61 Net-_D1-K_ Net-_D27-A_ 51k
C43 VOUTP 0 47uF
D11 VOUTP Net-_D11-K_ __D11
R38 VOUTN Net-_D1-K_ 249k
R54 Net-_D17-K_ NET0033 470
R62 VOUTN VOUTP 24k
R64 +3V3 Net-_D45-A_ 56
C5 VOUTP VOUTN 0.1uF
R15 0 /NET0058 10k
R20 Net-_D8-K_ Net-_U21-Y_ 1k
R88 +3V3 Net-_D10-A_ 27
C7 5V_switched 0 0.1uF
R36 NET0200 Net-_D32-K_ 1k
R45 0 Net-_D34-K_ 200
C68 5V_switched 0 1uF
C32 +12V 0 1uF
C18 +3V3 0 10uF
C73 +5V 0 10uF
C48 +12V NET0076 22pF
R89 NET0076 +12V 1.8Meg
L3 +5V Net-_D6-A_ 10u
R46 0 NET0076 205k
C8 0 +3V3 0.1uF
C37 0 +3V3 0.1uF
R19 Net-_D49-K_ NET0078 470
R77 Net-_C16-Pad2_ Net-_C38-Pad1_ 75R
R67 Net-_C85-Pad2_ Net-_C38-Pad1_ 75R
C85 NET0055 Net-_C85-Pad2_ 22nF
C26 0 Net-_C26-Pad2_ 0.1uF
R100 Net-_C79-Pad2_ Net-_C38-Pad1_ 75R
R48 Net-_C27-Pad2_ Net-_C38-Pad1_ 75R
C38 Net-_C38-Pad1_ 0 1nF
C79 NET0205 Net-_C79-Pad2_ 22nF
C27 NET0151 Net-_C27-Pad2_ 22nF
C16 NET0067 Net-_C16-Pad2_ 22nF
C54 Net-_U35-OSC1_ 0 18pF
C21 Net-_U35-OSC2_ 0 18pF
C14 Net-_U8-OSC2_ 0 18pF
C2 0 NET0131 0.1uF
C65 NET0131 0 0.1uF
C10 0 5V_switched_CAN 0.1uF
R69 /NET0054 Net-_R69-Pad2_ 120
C58 0 5V_switched_CAN 0.1uF
R6 /NET0165 Net-_R6-Pad2_ 120
C70 0 NET0131 0.1uF
R57 Net-_U35-_RESET_ NET0131 10k
C67 Net-_U8-OSC1_ 0 18pF
R87 Net-_U8-_RESET_ NET0131 10k
C84 NET0131 0 0.1uF
C80 VMOT 0 47uF
C36 VMOT 0 4.7uF
R98 VMOT /NET0146 100k
C52 VMOT 0 0.1uF
R40 Net-_J36-CC2_ 0 5.1k
R95 0 Net-_J36-CC1_ 5.1k
C6 +5V 0 47uF
C39 VMOT 0 47uF
L2 Net-_D7-K_ +5V 100u
C57 +5V 0 47uF
R55 +5V Net-_Q8-G_ 10k
R2 5V_CAN_ENABLE Net-_JP2-A_ 10k
R27 +3V3 Net-_U39-Y_ 10k
R82 +5V Net-_Q10-D_ 10k
R91 Net-_D12-K_ Net-_U39-A_ 130
R41 NET0121 +3V3 2.2k
R86 +3V3 Net-_U39-A_ 10k
R68 NET0031 +3V3 2.2k
C60 +3V3 0 0.1uF
C61 +3V3 0 470uF
R58 0 Net-_JP4-B_ 5.1k
R23 NET0057 /NET0109 27
R56 +3V3 NET0134 10k
C13 +3V3 0 0.1uF
R76 NET0143 /NET0045 27
R8 +3V3 NET0098 10k
R52 NET0064 Net-_Q1-G_ 100
R90 NET0195 Net-_Q14-G_ 100
R60 NET0150 Net-_Q12-G_ 100
R37 NET0190 Net-_Q16-G_ 100
R47 +3V3 NET0161 10k
C42 3.3V_PI_OUT 0 0.1uF
R96 3.3V_PI_OUT NET0114 10k
R4 3.3V_PI_OUT NET0198 10k
C71 +5V 0 0.1uF
C78 /NET0155 0 0.1uF
C29 +5V 0 10uF
C44 +5V 0 10uF
R51 VMOT Net-_R22-Pad1_ 50k
R11 Net-_D22-K_ Net-_U39-Y_ 130
R74 NET0145 +3V3 2.2k
R44 Net-_D19-K1_ 0 130
R5 Net-_D19-K2_ NET0036 130
R21 /NET0203 +3V3 2.2k
C33 +3V3 0 0.1uF
R65 /NET0180 0 5.1k
R22 Net-_R22-Pad1_ /NET0180 50k
C1 0 +3V3 1uF
R13 +3V3 /NET0068 10k
R7 Net-_D43-K_ /NET0203 130
R97 +3V3 /NET0203 10k

V_12V +12V 0 DC 12.0
V_3V3 +3V3 0 DC 3.3
V_5V +5V 0 DC 5.0

.control
tran 100u 10m
set filetype=ascii
write cm4-robot_raw.raw all
.endc

.end
