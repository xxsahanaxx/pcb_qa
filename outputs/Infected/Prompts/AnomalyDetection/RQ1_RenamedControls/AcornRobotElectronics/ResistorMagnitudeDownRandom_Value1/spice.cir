.title KiCad schematic

.model __D40 D

C28 0 Net-_U42-XTAL1_ 22pF
R74 Net-_U42-_RESET_ NET0192 10k
C29 0 NET0192 0.1uF
C70 0 NET0192 0.1uF
C54 Net-_U42-XTAL2_ 0 22pF
C6 0 Net-_U19-XTAL1_ 22pF
C33 Net-_U19-XTAL2_ 0 22pF
R80 Net-_U19-_RESET_ NET0192 10k
R48 NET0166 NET0192 1k
R6 NET0176 NET0192 1k
R7 /NET0151 NET0137 10k
C64 +3V3 0 0.1uF
R77 0 Net-_U2-SDO/SA1_ 5.1k
C30 Net-_U2-C1_ 0 0.1uF
C78 +3V3 0 1uF
C39 +3V3 0 0.1uF
C51 +5V 0 4.7uF
C60 +5V 0 1000uF
R59 NET0137 NET0170 2.2k
R53 NET0170 0 2.2k
R39 +3V3 NET0017 10k
R5 0 Net-_J1-CC1_ 5.1k
R73 Net-_D30-K_ Net-_D15-A_ 51k
C20 VOUTP 0 47uF
D40 VOUTP Net-_D40-K_ __D40
R10 VOUTN Net-_D30-K_ 249k
R99 Net-_D45-K_ NET0145 470
R47 VOUTN VOUTP 24k
R76 +3V3 Net-_D14-A_ 56
C2 VOUTP VOUTN 0.1uF
R14 0 /NET0015 10k
R22 Net-_D19-K_ Net-_U57-Y_ 1k
R41 +3V3 Net-_D3-A_ 27
C42 5V_switched 0 0.1uF
R55 NET0031 Net-_D23-K_ 1k
R25 0 Net-_D36-K_ 200
C9 5V_switched 0 1uF
C24 +12V 0 1uF
C66 +3V3 0 10uF
C48 +5V 0 10uF
C76 +12V NET0097 22pF
R8 NET0097 +12V 1.8Meg
L3 +5V Net-_D48-A_ 10u
R28 0 NET0097 205k
C5 0 +3V3 0.1uF
C21 0 +3V3 0.1uF
R18 Net-_D28-K_ NET0038 470
R33 Net-_C38-Pad2_ Net-_C67-Pad1_ 75R
R89 Net-_C11-Pad2_ Net-_C67-Pad1_ 75R
C11 NET0197 Net-_C11-Pad2_ 22nF
C31 0 Net-_C31-Pad2_ 0.1uF
R19 Net-_C19-Pad2_ Net-_C67-Pad1_ 75R
R85 Net-_C34-Pad2_ Net-_C67-Pad1_ 75R
C67 Net-_C67-Pad1_ 0 1nF
C19 NET0096 Net-_C19-Pad2_ 22nF
C34 NET0087 Net-_C34-Pad2_ 22nF
C38 NET0111 Net-_C38-Pad2_ 22nF
C45 Net-_U27-OSC1_ 0 18pF
C36 Net-_U27-OSC2_ 0 18pF
C14 Net-_U46-OSC2_ 0 18pF
C41 0 NET0192 0.1uF
C84 NET0192 0 0.1uF
C77 0 5V_switched_CAN 0.1uF
R102 /NET0164 Net-_R102-Pad2_ 120
C80 0 5V_switched_CAN 0.1uF
R36 /NET0142 Net-_R36-Pad2_ 120
C40 0 NET0192 0.1uF
R30 Net-_U27-_RESET_ NET0192 10k
C1 Net-_U46-OSC1_ 0 18pF
R35 Net-_U46-_RESET_ NET0192 10k
C37 NET0192 0 0.1uF
C83 VMOT 0 47uF
C52 VMOT 0 4.7uF
R61 VMOT /NET0008 100k
C26 VMOT 0 0.1uF
R49 Net-_J1-CC2_ 0 5.1k
C17 +5V 0 47uF
C58 VMOT 0 47uF
L2 Net-_D26-K_ +5V 100u
C44 +5V 0 47uF
R81 +5V Net-_Q7-G_ 10k
R43 5V_CAN_ENABLE Net-_JP21-A_ 10k
R46 +3V3 Net-_U40-A_ 10k
R87 +5V Net-_Q8-D_ 10k
R45 Net-_D1-K_ Net-_U55-Y_ 130
R40 NET0175 +3V3 2.2k
R101 +3V3 Net-_U55-Y_ 10k
R70 NET0113 +3V3 2.2k
C56 +3V3 0 0.1uF
C23 +3V3 0 470uF
R42 0 Net-_JP20-B_ 5.1k
C57 3.3V_PI_OUT 0 0.1uF
R13 3.3V_PI_OUT NET0128 10k
R95 3.3V_PI_OUT NET0064 10k
R52 NET0107 /NET0016 27
R26 +3V3 NET0009 10k
C50 +3V3 0 0.1uF
R71 NET0094 /NET0129 27
R68 +3V3 NET0072 10k
R58 +3V3 NET0057 10k
R32 NET0209 Net-_Q6-G_ 100
R27 NET0207 Net-_Q11-G_ 100
R88 NET0077 Net-_Q1-G_ 100
R38 NET0106 Net-_Q12-G_ 100
C25 +5V 0 0.1uF
C68 /NET0021 0 0.1uF
C27 +5V 0 10uF
C46 +5V 0 10uF
R72 VMOT Net-_R72-Pad2_ 50k
R75 Net-_D20-K_ Net-_U40-A_ 130
R69 NET0213 +3V3 2.2k
R29 Net-_D37-K1_ 0 130
R56 Net-_D37-K2_ NET0143 130
R79 /NET0054 +3V3 2.2k
C7 +3V3 0 0.1uF
R11 /NET0180 0 5.1k
R78 Net-_R72-Pad2_ /NET0180 50k
C82 0 +3V3 1uF
R9 +3V3 /NET0132 10k
R44 Net-_D10-K_ /NET0054 130
R84 +3V3 /NET0054 10k

V_12V +12V 0 DC 12.0
V_3V3 +3V3 0 DC 3.3
V_5V +5V 0 DC 5.0

.control
tran 100u 10m
set filetype=ascii
write cm4-robot_raw.raw all
.endc

.end
