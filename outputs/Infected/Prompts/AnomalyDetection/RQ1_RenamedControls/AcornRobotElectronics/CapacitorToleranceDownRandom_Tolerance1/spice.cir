.title KiCad schematic

.model __D14 D

C82 0 Net-_U21-XTAL1_ 22pF
R55 Net-_U21-_RESET_ NET0143 10k
C39 0 NET0143 0.1uF
C20 0 NET0143 0.1uF
C6 Net-_U21-XTAL2_ 0 22pF
C61 0 Net-_U12-XTAL1_ 22pF
C63 Net-_U12-XTAL2_ 0 22pF
R71 Net-_U12-_RESET_ NET0143 10k
R72 NET0167 NET0143 1k
R92 NET0199 NET0143 1k
R95 /NET0043 NET0083 10k
C56 +3V3 0 0.1uF
R30 0 Net-_U35-SDO/SA1_ 5.1k
C24 Net-_U35-C1_ 0 0.1uF
C74 +3V3 0 1uF
C41 +3V3 0 0.1uF
C68 +5V 0 4.7uF
C51 +5V 0 1000uF
R77 NET0083 NET0152 2.2k
R10 +3V3 NET0064 10k
R74 NET0152 0 2.2k
R53 Net-_D37-K_ Net-_D33-A_ 51k
C12 VOUTP 0 47uF
D14 VOUTP Net-_D14-K_ __D14
R81 VOUTN Net-_D37-K_ 249k
R51 Net-_D22-K_ NET0020 470
R54 VOUTN VOUTP 24k
R65 +3V3 Net-_D42-A_ 56
C71 VOUTP VOUTN 0.1uF
R28 Net-_D5-K_ Net-_U6-Y_ 1k
R41 0 /NET0131 10k
R91 +3V3 Net-_D48-A_ 27
C13 5V_switched 0 0.1uF
R49 NET0122 Net-_D6-K_ 1k
R100 0 Net-_D23-K_ 200
C59 5V_switched 0 1uF
C78 +12V 0 1uF
C47 +3V3 0 10uF
C9 +5V 0 10uF
C70 +12V NET0188 22pF
R6 NET0188 +12V 1.8Meg
L1 +5V Net-_D46-A_ 10u
R62 0 NET0188 205k
C65 0 +3V3 0.1uF
C50 0 +3V3 0.1uF
R12 Net-_D20-K_ NET0176 470
R40 Net-_C15-Pad2_ Net-_C57-Pad1_ 75R
R26 Net-_C5-Pad2_ Net-_C57-Pad1_ 75R
C5 NET0128 Net-_C5-Pad2_ 22nF
C18 0 Net-_C18-Pad2_ 0.1uF
R78 Net-_C46-Pad2_ Net-_C57-Pad1_ 75R
R102 Net-_C25-Pad2_ Net-_C57-Pad1_ 75R
C57 Net-_C57-Pad1_ 0 1nF
C46 NET0075 Net-_C46-Pad2_ 22nF
C25 NET0145 Net-_C25-Pad2_ 22nF
C15 NET0007 Net-_C15-Pad2_ 22nF
C3 Net-_U44-OSC1_ 0 18pF
C80 Net-_U44-OSC2_ 0 18pF
C2 Net-_U4-OSC2_ 0 18pF
C1 0 NET0143 0.1uF
C26 NET0143 0 0.1uF
C66 0 5V_switched_CAN 0.1uF
R38 /NET0158 Net-_R38-Pad2_ 120
C73 0 5V_switched_CAN 0.1uF
R70 /NET0154 Net-_R70-Pad2_ 120
C32 0 NET0143 0.1uF
R2 Net-_U44-_RESET_ NET0143 10k
C72 Net-_U4-OSC1_ 0 18pF
R89 Net-_U4-_RESET_ NET0143 10k
C42 NET0143 0 0.1uF
C86 VMOT 0 47uF
C77 VMOT 0 4.7uF
R11 VMOT /NET0030 100k
C58 VMOT 0 0.1uF
R20 Net-_J15-CC2_ 0 5.1k
R60 0 Net-_J15-CC1_ 5.1k
C40 +5V 0 47uF
C7 VMOT 0 47uF
L3 Net-_D19-K_ +5V 100u
C36 +5V 0 47uF
R17 +5V Net-_Q13-G_ 10k
R79 5V_CAN_ENABLE Net-_JP24-A_ 10k
R13 +3V3 Net-_U34-Y_ 10k
R58 +5V Net-_Q12-D_ 10k
R88 Net-_D41-K_ Net-_U33-Y_ 130
R21 NET0109 +3V3 2.2k
R34 +3V3 Net-_U33-Y_ 10k
R35 NET0010 +3V3 2.2k
C8 +3V3 0 0.1uF
C19 +3V3 0 470uF
R22 0 Net-_JP7-B_ 5.1k
C49 3.3V_PI_OUT 0 0.1uF
R75 3.3V_PI_OUT NET0081 10k
R84 3.3V_PI_OUT NET0088 10k
R43 NET0026 /NET0014 27
R25 +3V3 NET0069 10k
C48 +3V3 0 0.1uF
R90 NET0177 /NET0034 27
R9 +3V3 NET0012 10k
R33 +3V3 NET0107 10k
R36 NET0073 Net-_Q16-G_ 100
R32 NET0099 Net-_Q11-G_ 100
R67 NET0214 Net-_Q9-G_ 100
R66 NET0139 Net-_Q2-G_ 100
C23 +5V 0 0.1uF
C62 /NET0001 0 0.1uF
C84 +5V 0 10uF
C38 +5V 0 10uF
R45 VMOT Net-_R45-Pad2_ 50k
R31 Net-_D49-K_ Net-_U34-Y_ 130
R59 NET0003 +3V3 2.2k
R57 Net-_D39-K1_ 0 130
R23 Net-_D39-K2_ NET0121 130
R64 /NET0157 +3V3 2.2k
C22 +3V3 0 0.1uF
R24 /NET0042 0 5.1k
R69 Net-_R45-Pad2_ /NET0042 50k
C79 0 +3V3 1uF
R4 +3V3 /NET0208 10k
R80 Net-_D26-K_ /NET0157 130
R52 +3V3 /NET0157 10k

V_12V +12V 0 DC 12.0
V_3V3 +3V3 0 DC 3.3
V_5V +5V 0 DC 5.0

.control
tran 100u 10m
set filetype=ascii
write cm4-robot_raw.raw all
.endc

.end
