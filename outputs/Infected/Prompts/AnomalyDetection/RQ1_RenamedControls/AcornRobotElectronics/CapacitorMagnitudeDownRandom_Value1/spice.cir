.title KiCad schematic

.model __D42 D

C23 0 Net-_U30-XTAL1_ 22pF
R68 Net-_U30-_RESET_ NET0064 10k
C69 0 NET0064 0.1uF
C2 0 NET0064 0.1uF
C5 Net-_U30-XTAL2_ 0 22pF
C47 0 Net-_U57-XTAL1_ 22pF
C59 Net-_U57-XTAL2_ 0 22pF
R102 Net-_U57-_RESET_ NET0064 10k
R59 NET0029 NET0064 1k
R58 NET0033 NET0064 1k
R36 /NET0094 NET0114 10k
C46 +3V3 0 0.1uF
R81 0 Net-_U29-SDO/SA1_ 5.1k
C54 Net-_U29-C1_ 0 0.1uF
C70 +3V3 0 1uF
C60 +3V3 0 0.1uF
C12 +5V 0 4.7uF
C4 +5V 0 1000uF
R24 NET0114 NET0050 2.2k
R56 +3V3 NET0163 10k
R23 NET0050 0 2.2k
R101 Net-_D34-K_ Net-_D33-A_ 51k
C21 VOUTP 0 47uF
D42 VOUTP Net-_D42-K_ __D42
R88 VOUTN Net-_D34-K_ 249k
R57 Net-_D36-K_ NET0155 470
R46 VOUTN VOUTP 24k
R69 +3V3 Net-_D5-A_ 56
C71 VOUTP VOUTN 0.1uF
R91 0 /NET0023 10k
R4 Net-_D9-K_ Net-_U22-Y_ 1k
R60 +3V3 Net-_D38-A_ 27
C52 5V_switched 0 0.1uF
R35 NET0061 Net-_D12-K_ 1k
R96 0 Net-_D7-K_ 200
C66 5V_switched 0 1uF
C56 +12V 0 1uF
C58 +3V3 0 10uF
C3 +5V 0 10uF
C17 +12V NET0151 22pF
R63 NET0151 +12V 1.8Meg
L1 +5V Net-_D43-A_ 10u
R9 0 NET0151 205k
C85 0 +3V3 0.1uF
C38 0 +3V3 0.1uF
R70 Net-_D11-K_ NET0090 470
R18 Net-_C51-Pad2_ Net-_C67-Pad1_ 75R
R27 Net-_C79-Pad2_ Net-_C67-Pad1_ 75R
C79 NET0043 Net-_C79-Pad2_ 22nF
C64 0 Net-_C64-Pad2_ 0.1uF
R74 Net-_C39-Pad2_ Net-_C67-Pad1_ 75R
R14 Net-_C48-Pad2_ Net-_C67-Pad1_ 75R
C67 Net-_C67-Pad1_ 0 1nF
C39 NET0030 Net-_C39-Pad2_ 22nF
C48 NET0097 Net-_C48-Pad2_ 22nF
C51 NET0086 Net-_C51-Pad2_ 22nF
C29 Net-_U40-OSC1_ 0 18pF
C30 Net-_U40-OSC2_ 0 18pF
C24 Net-_U34-OSC2_ 0 18pF
C40 0 NET0064 0.1uF
C78 NET0064 0 0.1uF
C13 0 5V_switched_CAN 0.1uF
R16 /NET0195 Net-_R16-Pad2_ 120
C73 0 5V_switched_CAN 0.1uF
R61 /NET0132 Net-_R61-Pad2_ 120
C33 0 NET0064 0.1uF
R50 Net-_U40-_RESET_ NET0064 10k
C18 Net-_U34-OSC1_ 0 18pF
R8 Net-_U34-_RESET_ NET0064 10k
C10 NET0064 0 0.1uF
C55 VMOT 0 47uF
C61 VMOT 0 4.7uF
R33 VMOT /NET0075 100k
C65 VMOT 0 0.1uF
R75 Net-_J6-CC2_ 0 5.1k
R21 0 Net-_J6-CC1_ 5.1k
C68 +5V 0 47uF
C37 VMOT 0 47uF
L3 Net-_D26-K_ +5V 100u
C22 +5V 0 47uF
R67 +5V Net-_Q7-G_ 10k
R1 5V_CAN_ENABLE Net-_JP1-A_ 10k
R95 +3V3 Net-_U28-A_ 10k
R72 +5V Net-_Q14-G_ 10k
R55 Net-_D40-K_ Net-_U36-A_ 130
R3 NET0203 +3V3 2.2k
R40 +3V3 Net-_U36-A_ 10k
R5 NET0065 +3V3 2.2k
C14 +3V3 0 0.1uF
C84 +3V3 0 470uF
R37 0 Net-_JP3-B_ 5.1k
R53 NET0005 /NET0100 27
R30 +3V3 NET0049 10k
C16 +3V3 0 0.1uF
R51 NET0092 /NET0093 27
R76 +3V3 NET0107 10k
R78 NET0167 Net-_Q10-G_ 100
R71 NET0191 Net-_Q1-G_ 100
R93 NET0105 Net-_Q11-G_ 100
R47 NET0040 Net-_Q8-G_ 100
R28 +3V3 NET0134 10k
C9 3.3V_PI_OUT 0 0.1uF
R86 3.3V_PI_OUT NET0039 10k
R64 3.3V_PI_OUT NET0046 10k
C28 +5V 0 0.1uF
C83 /NET0200 0 0.1uF
C8 +5V 0 10uF
C15 +5V 0 10uF
R94 VMOT Net-_R15-Pad1_ 50k
R12 Net-_D8-K_ Net-_U28-A_ 130
R19 NET0072 +3V3 2.2k
R10 Net-_D20-K1_ 0 130
R83 Net-_D20-K2_ NET0209 130
R97 /NET0003 +3V3 2.2k
C57 +3V3 0 0.1uF
R41 /NET0057 0 5.1k
R15 Net-_R15-Pad1_ /NET0057 50k
C35 0 +3V3 1uF
R73 +3V3 /NET0154 10k
R87 Net-_D45-K_ /NET0003 130
R77 +3V3 /NET0003 10k

V_12V +12V 0 DC 12.0
V_3V3 +3V3 0 DC 3.3
V_5V +5V 0 DC 5.0

.control
tran 100u 10m
set filetype=ascii
write cm4-robot_raw.raw all
.endc

.end
