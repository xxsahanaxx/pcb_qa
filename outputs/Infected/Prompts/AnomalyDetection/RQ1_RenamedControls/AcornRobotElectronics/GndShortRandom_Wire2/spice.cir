.title KiCad schematic

.model __D45 D

C68 0 Net-_U33-XTAL1_ 22pF
R52 Net-_U33-_RESET_ NET0192 10k
C8 0 NET0192 0.1uF
C62 0 NET0192 0.1uF
C49 Net-_U33-XTAL2_ 0 22pF
C69 0 Net-_U48-XTAL1_ 22pF
C81 Net-_U48-XTAL2_ 0 22pF
R49 Net-_U48-_RESET_ NET0192 10k
R13 NET0206 NET0192 1k
R24 NET0177 NET0192 1k
R69 /NET0198 NET0032 10k
C77 +3V3 0 0.1uF
R1 0 Net-_U57-SDO/SA1_ 5.1k
C64 Net-_U57-C1_ 0 0.1uF
C80 +3V3 0 1uF
C41 +3V3 0 0.1uF
C56 +5V 0 4.7uF
C23 +5V 0 1000uF
R90 NET0032 NET0186 2.2k
R63 +3V3 NET0187 10k
R3 NET0186 0 2.2k
R55 Net-_D15-K_ Net-_D11-A_ 51k
C45 VOUTP 0 47uF
D45 VOUTP Net-_D45-K_ __D45
R22 VOUTN Net-_D15-K_ 249k
R45 Net-_D34-K_ NET0182 470
R100 VOUTN VOUTP 24k
R92 +3V3 Net-_D25-A_ 56
C43 VOUTP VOUTN 0.1uF
R34 0 /NET0042 10k
R67 Net-_D16-K_ Net-_U29-Y_ 1k
R42 +3V3 Net-_D4-A_ 27
C65 5V_switched 0 0.1uF
R57 NET0014 Net-_D35-K_ 1k
R17 0 Net-_D18-K_ 200
C3 5V_switched 0 1uF
C2 +12V 0 1uF
C38 +3V3 0 10uF
C13 +5V 0 10uF
C11 +12V NET0189 22pF
R15 NET0189 +12V 1.8Meg
L3 +5V Net-_D8-A_ 10u
R29 0 NET0189 205k
C6 0 +3V3 0.1uF
C15 0 +3V3 0.1uF
R87 Net-_D40-K_ NET0133 470
R86 Net-_C16-Pad2_ Net-_C70-Pad1_ 75R
R79 Net-_C83-Pad2_ Net-_C70-Pad1_ 75R
C83 NET0167 Net-_C83-Pad2_ 22nF
C63 0 Net-_C63-Pad2_ 0.1uF
R33 Net-_C40-Pad2_ Net-_C70-Pad1_ 75R
R99 Net-_C24-Pad2_ Net-_C70-Pad1_ 75R
C70 Net-_C70-Pad1_ 0 1nF
C40 NET0084 Net-_C40-Pad2_ 22nF
C24 NET0066 Net-_C24-Pad2_ 22nF
C16 NET0108 Net-_C16-Pad2_ 22nF
C12 Net-_U17-OSC1_ 0 18pF
C79 Net-_U17-OSC2_ 0 18pF
C57 Net-_U30-OSC2_ 0 18pF
C53 0 NET0192 0.1uF
C66 NET0192 0 0.1uF
C71 0 5V_switched_CAN 0.1uF
R20 /NET0111 Net-_R20-Pad2_ 120
C22 0 5V_switched_CAN 0.1uF
R28 /NET0155 Net-_R28-Pad2_ 120
C85 0 NET0192 0.1uF
R48 Net-_U17-_RESET_ NET0192 10k
C54 Net-_U30-OSC1_ 0 18pF
R80 Net-_U30-_RESET_ NET0192 10k
C36 NET0192 0 0.1uF
C51 VMOT 0 47uF
C26 VMOT 0 4.7uF
R26 VMOT /NET0199 100k
C76 VMOT 0 0.1uF
R73 Net-_J38-CC2_ 0 5.1k
R84 0 Net-_J38-CC1_ 5.1k
C19 +5V 0 47uF
C5 VMOT 0 47uF
L2 Net-_D47-K_ +5V 100u
C10 +5V 0 47uF
R51 +5V Net-_Q7-G_ 10k
R56 5V_CAN_ENABLE Net-_JP11-A_ 10k
R53 +3V3 Net-_U24-Y_ 10k
R88 +5V Net-_Q5-D_ 10k
R60 Net-_D17-K_ Net-_U24-A_ 130
R93 NET0050 +3V3 2.2k
R77 +3V3 Net-_U24-A_ 10k
R23 NET0211 +3V3 2.2k
C21 +3V3 0 0.1uF
C52 +3V3 0 470uF
R10 0 Net-_JP22-B_ 5.1k
R66 NET0090 /NET0170 27
R96 +3V3 NET0067 10k
C39 +3V3 0 0.1uF
R85 NET0096 /NET0210 27
R91 +3V3 NET0145 10k
R6 NET0010 Net-_Q11-G_ 100
R83 NET0201 Net-_Q9-G_ 100
R44 NET0138 Net-_Q15-G_ 100
R81 NET0193 Net-_Q2-G_ 100
R46 +3V3 NET0159 10k
C31 3.3V_PI_OUT 0 0.1uF
R14 3.3V_PI_OUT NET0004 10k
R59 3.3V_PI_OUT NET0039 10k
C7 +5V 0 0.1uF
C58 /NET0047 0 0.1uF
C32 +5V 0 10uF
C50 +5V 0 10uF
R11 VMOT Net-_R11-Pad2_ 50k
R31 Net-_D31-K_ Net-_U24-Y_ 130
R82 NET0104 +3V3 2.2k
R50 Net-_D39-K1_ 0 130
R37 Net-_D39-K2_ NET0058 130
R70 /NET0008 +3V3 2.2k
C9 +3V3 0 0.1uF
R47 /NET0121 0 5.1k
R62 Net-_R11-Pad2_ /NET0121 50k
C82 0 +3V3 1uF
R39 +3V3 /NET0065 10k
R76 Net-_D9-K_ /NET0008 130
R9 +3V3 /NET0008 10k

V_12V +12V 0 DC 12.0
V_3V3 +3V3 0 DC 3.3
V_5V +5V 0 DC 5.0

.control
tran 100u 10m
set filetype=ascii
write cm4-robot_raw.raw all
.endc

.end
