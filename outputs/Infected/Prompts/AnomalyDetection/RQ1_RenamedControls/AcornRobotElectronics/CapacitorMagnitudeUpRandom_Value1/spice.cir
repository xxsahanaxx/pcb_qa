.title KiCad schematic

.model __D41 D

C83 0 Net-_U12-XTAL1_ 22pF
R72 Net-_U12-_RESET_ NET0180 10k
C14 0 NET0180 0.1uF
C15 0 NET0180 0.1uF
C27 Net-_U12-XTAL2_ 0 22pF
C67 0 Net-_U35-XTAL1_ 22pF
C58 Net-_U35-XTAL2_ 0 22pF
R91 Net-_U35-_RESET_ NET0180 10k
R19 NET0149 NET0180 1k
R9 NET0073 NET0180 1k
R10 /NET0013 NET0078 10k
C84 +3V3 0 0.1uF
R13 0 Net-_U8-SDO/SA1_ 5.1k
C63 Net-_U8-C1_ 0 0.1uF
C12 +3V3 0 1uF
C54 +3V3 0 0.1uF
C34 +5V 0 4.7uF
C28 +5V 0 1000uF
R86 NET0078 NET0091 2.2k
R20 NET0091 0 2.2k
R57 +3V3 NET0051 10k
R1 0 Net-_J16-CC1_ 5.1k
R34 Net-_D35-K_ Net-_D44-A_ 51k
C52 VOUTP 0 47uF
D41 VOUTP Net-_D41-K_ __D41
R17 VOUTN Net-_D35-K_ 249k
R47 Net-_D47-K_ NET0194 470
R4 VOUTN VOUTP 24k
R92 +3V3 Net-_D9-A_ 56
C64 VOUTP VOUTN 0.1uF
R77 0 /NET0179 10k
R43 Net-_D29-K_ Net-_U19-Y_ 1k
R15 +3V3 Net-_D20-A_ 27
C17 5V_switched 0 0.1uF
R38 NET0087 Net-_D25-K_ 1k
R50 0 Net-_D10-K_ 200
C3 5V_switched 0 1uF
C19 +12V 0 1uF
C46 +3V3 0 10uF
C78 +5V 0 10uF
C13 +12V NET0047 22pF
R24 NET0047 +12V 1.8Meg
L1 +5V Net-_D40-A_ 10u
R31 0 NET0047 205k
C31 0 +3V3 0.1uF
C47 0 +3V3 0.1uF
R95 Net-_D30-K_ NET0145 470
R39 Net-_C11-Pad2_ Net-_C86-Pad1_ 75R
R79 Net-_C85-Pad2_ Net-_C86-Pad1_ 75R
C85 NET0042 Net-_C85-Pad2_ 22nF
C22 0 Net-_C22-Pad2_ 0.1uF
R12 Net-_C49-Pad2_ Net-_C86-Pad1_ 75R
R68 Net-_C70-Pad2_ Net-_C86-Pad1_ 75R
C86 Net-_C86-Pad1_ 0 1nF
C49 NET0061 Net-_C49-Pad2_ 22nF
C70 NET0006 Net-_C70-Pad2_ 22nF
C11 NET0092 Net-_C11-Pad2_ 22nF
C82 Net-_U28-OSC1_ 0 18pF
C23 Net-_U28-OSC2_ 0 18pF
C5 Net-_U38-OSC2_ 0 18pF
C56 0 NET0180 0.1uF
C37 NET0180 0 0.1uF
C25 0 5V_switched_CAN 0.1uF
R58 /NET0201 Net-_R58-Pad2_ 120
C79 0 5V_switched_CAN 0.1uF
R56 /NET0156 Net-_R56-Pad2_ 120
C50 0 NET0180 0.1uF
R53 Net-_U28-_RESET_ NET0180 10k
C35 Net-_U38-OSC1_ 0 18pF
R32 Net-_U38-_RESET_ NET0180 10k
C42 NET0180 0 0.1uF
C61 VMOT 0 47uF
C18 VMOT 0 4.7uF
R21 VMOT /NET0111 100k
C73 VMOT 0 0.1uF
R90 Net-_J16-CC2_ 0 5.1k
C71 +5V 0 47uF
C72 VMOT 0 47uF
L2 Net-_D42-K_ +5V 100u
C24 +5V 0 47uF
R73 +5V Net-_Q2-G_ 10k
R88 5V_CAN_ENABLE Net-_JP10-A_ 10k
R25 +3V3 Net-_U14-Y_ 10k
R71 +5V Net-_Q10-D_ 10k
R59 Net-_D15-K_ Net-_U14-A_ 130
R45 NET0022 +3V3 2.2k
R35 +3V3 Net-_U14-A_ 10k
R52 NET0070 +3V3 2.2k
C68 +3V3 0 0.1uF
C75 +3V3 0 470uF
R82 0 Net-_JP1-B_ 5.1k
R23 NET0158 /NET0186 27
R33 +3V3 NET0203 10k
C33 +3V3 0 0.1uF
R42 NET0003 /NET0108 27
R8 +3V3 NET0123 10k
R3 NET0120 Net-_Q6-G_ 100
R29 NET0196 Net-_Q3-G_ 100
R75 NET0118 Net-_Q13-G_ 100
R78 NET0081 Net-_Q1-G_ 100
R100 +3V3 NET0148 10k
C39 3.3V_PI_OUT 0 0.1uF
R11 3.3V_PI_OUT NET0146 10k
R5 3.3V_PI_OUT NET0043 10k
C43 +5V 0 0.1uF
C53 /NET0027 0 0.1uF
C29 +5V 0 10uF
C4 +5V 0 10uF
R18 VMOT Net-_R18-Pad2_ 50k
R36 Net-_D14-K_ Net-_U14-Y_ 130
R44 NET0012 +3V3 2.2k
R65 Net-_D18-K1_ 0 130
R16 Net-_D18-K2_ NET0029 130
R97 /NET0079 +3V3 2.2k
C7 +3V3 0 0.1uF
R74 /NET0168 0 5.1k
R37 Net-_R18-Pad2_ /NET0168 50k
C57 0 +3V3 1uF
R84 +3V3 /NET0211 10k
R30 Net-_D12-K_ /NET0079 130
R26 +3V3 /NET0079 10k

V_12V +12V 0 DC 12.0
V_3V3 +3V3 0 DC 3.3
V_5V +5V 0 DC 5.0

.control
tran 100u 10m
set filetype=ascii
write cm4-robot_raw.raw all
.endc

.end
