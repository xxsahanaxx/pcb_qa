.title KiCad schematic

.model __D48 D

C1 0 Net-_U6-XTAL1_ 22pF
R98 Net-_U6-_RESET_ NET0062 10k
C38 0 NET0062 0.1uF
C62 0 NET0062 0.1uF
C39 Net-_U6-XTAL2_ 0 22pF
C86 0 Net-_U32-XTAL1_ 22pF
C69 Net-_U32-XTAL2_ 0 22pF
R79 Net-_U32-_RESET_ NET0062 10k
R48 NET0198 NET0062 1k
R69 NET0035 NET0062 1k
R16 /NET0133 NET0021 10k
C29 +3V3 0 0.1uF
R87 0 Net-_U35-SDO/SA1_ 5.1k
C13 Net-_U35-C1_ 0 0.1uF
C74 +3V3 0 1uF
C8 +3V3 0 0.1uF
C71 +5V 0 4.7uF
C66 +5V 0 1000uF
R21 NET0021 NET0012 2.2k
R74 +3V3 NET0093 10k
R101 NET0012 0 2.2k
R85 Net-_D28-K_ Net-_D29-A_ 51k
C68 VOUTP 0 47uF
D48 VOUTP Net-_D48-K_ __D48
R13 VOUTN Net-_D28-K_ 249k
R80 Net-_D37-K_ NET0015 470
R29 VOUTN VOUTP 24k
R7 +3V3 Net-_D45-A_ 56
C84 VOUTP VOUTN 0.1uF
R70 0 /NET0207 10k
R41 Net-_D19-K_ Net-_U3-Y_ 1k
R66 +3V3 Net-_D30-A_ 27
C30 5V_switched 0 0.1uF
R86 NET0051 Net-_D21-K_ 1k
R1 0 Net-_D5-K_ 200
C31 5V_switched 0 1uF
C19 +12V 0 1uF
C24 +3V3 0 10uF
C5 +5V 0 10uF
C47 +12V NET0162 22pF
R37 NET0162 +12V 1.8Meg
L3 +5V Net-_D44-A_ 10u
R62 0 NET0162 205k
C40 0 +3V3 0.1uF
C46 0 +3V3 0.1uF
R50 Net-_D43-K_ NET0095 470
R33 Net-_C35-Pad2_ Net-_C53-Pad1_ 75R
R90 Net-_C34-Pad2_ Net-_C53-Pad1_ 75R
C34 NET0025 Net-_C34-Pad2_ 22nF
C72 0 Net-_C72-Pad2_ 0.1uF
R36 Net-_C59-Pad2_ Net-_C53-Pad1_ 75R
R55 Net-_C14-Pad2_ Net-_C53-Pad1_ 75R
C53 Net-_C53-Pad1_ 0 1nF
C59 NET0132 Net-_C59-Pad2_ 22nF
C14 NET0178 Net-_C14-Pad2_ 22nF
C35 NET0099 Net-_C35-Pad2_ 22nF
C17 Net-_U30-OSC1_ 0 18pF
C85 Net-_U30-OSC2_ 0 18pF
C48 Net-_U37-OSC2_ 0 18pF
C76 0 NET0062 0.1uF
C54 NET0062 0 0.1uF
C7 0 5V_switched_CAN 0.1uF
R4 /NET0040 Net-_R4-Pad2_ 120
C44 0 5V_switched_CAN 0.1uF
R44 /NET0083 Net-_R44-Pad2_ 120
C60 0 NET0062 0.1uF
R40 Net-_U30-_RESET_ NET0062 10k
C78 Net-_U37-OSC1_ 0 18pF
R60 Net-_U37-_RESET_ NET0062 10k
C64 NET0062 0 0.1uF
C77 VMOT 0 47uF
C56 VMOT 0 4.7uF
R54 VMOT /NET0150 100k
C9 VMOT 0 0.1uF
R43 Net-_J4-CC2_ 0 5.1k
R77 0 Net-_J4-CC1_ 5.1k
C50 +5V 0 47uF
C11 VMOT 0 47uF
L2 Net-_D4-K_ +5V 100u
C20 +5V 0 47uF
R39 +5V Net-_Q2-G_ 10k
R35 5V_CAN_ENABLE Net-_JP22-A_ 10k
R9 +3V3 Net-_U36-Y_ 10k
R31 +5V Net-_Q16-G_ 10k
R49 Net-_D26-K_ Net-_U31-Y_ 130
R27 NET0110 +3V3 2.2k
R11 +3V3 Net-_U31-Y_ 10k
R67 NET0057 +3V3 2.2k
C36 +3V3 0 0.1uF
C45 +3V3 0 470uF
R76 0 Net-_JP8-B_ 5.1k
C73 3.3V_PI_OUT 0 0.1uF
R72 3.3V_PI_OUT NET0065 10k
R3 3.3V_PI_OUT NET0212 10k
R56 NET0068 /NET0209 27
R78 +3V3 NET0005 10k
C3 +3V3 0 0.1uF
R26 NET0205 /NET0197 27
R88 +3V3 NET0104 10k
R92 +3V3 NET0166 10k
R75 NET0173 Net-_Q1-G_ 100
R12 NET0183 Net-_Q11-G_ 100
R83 NET0151 Net-_Q9-G_ 100
R25 NET0192 Net-_Q5-G_ 100
C82 +5V 0 0.1uF
C2 /NET0157 0 0.1uF
C23 +5V 0 10uF
C49 +5V 0 10uF
R99 VMOT Net-_R47-Pad1_ 50k
R65 Net-_D24-K_ Net-_U36-Y_ 130
R71 NET0016 +3V3 2.2k
R30 Net-_D1-K1_ 0 130
R45 Net-_D1-K2_ NET0010 130
R14 /NET0129 +3V3 2.2k
C26 +3V3 0 0.1uF
R51 /NET0003 0 5.1k
R47 Net-_R47-Pad1_ /NET0003 50k
C70 0 +3V3 1uF
R23 +3V3 /NET0050 10k
R94 Net-_D39-K_ /NET0129 130
R20 +3V3 /NET0129 10k

V_12V +12V 0 DC 12.0
V_3V3 +3V3 0 DC 3.3
V_5V +5V 0 DC 5.0

.control
tran 100u 10m
set filetype=ascii
write cm4-robot_raw.raw all
.endc

.end
