.title KiCad schematic

.model __D40 D

C6 0 Net-_U56-XTAL1_ 22pF
R42 Net-_U56-_RESET_ NET0071 10k
C45 0 NET0071 0.1uF
C27 0 NET0071 0.1uF
C52 Net-_U56-XTAL2_ 0 22pF
C29 0 Net-_U26-XTAL1_ 22pF
C25 Net-_U26-XTAL2_ 0 22pF
R83 Net-_U26-_RESET_ NET0071 10k
R20 NET0167 NET0071 1k
R100 NET0166 NET0071 1k
R78 /NET0043 NET0172 10k
C84 +3V3 0 0.1uF
R37 0 Net-_U33-SDO/SA1_ 5.1k
C75 Net-_U33-C1_ 0 0.1uF
C22 +3V3 0 1uF
C37 +3V3 0 0.1uF
C54 +5V 0 4.7uF
C33 +5V 0 1000uF
R92 NET0172 NET0083 2.2k
R11 +3V3 NET0021 10k
R73 NET0083 0 2.2k
R91 Net-_D35-K_ Net-_D10-A_ 51k
C47 VOUTP 0 47uF
D40 VOUTP Net-_D40-K_ __D40
R80 VOUTN Net-_D35-K_ 249k
R7 Net-_D39-K_ NET0187 470
R98 VOUTN VOUTP 24k
R69 +3V3 Net-_D44-A_ 56
C32 VOUTP VOUTN 0.1uF
R19 0 /NET0102 10k
R52 Net-_D31-K_ Net-_U20-Y_ 1k
R30 +3V3 Net-_D48-A_ 27
C59 5V_switched 0 0.1uF
R21 NET0082 Net-_D15-K_ 1k
R6 0 Net-_D23-K_ 200
C4 5V_switched 0 1uF
C79 +12V 0 1uF
C76 +3V3 0 10uF
C28 +5V 0 10uF
C53 +12V NET0177 22pF
R38 NET0177 +12V 1.8Meg
L1 +5V Net-_D20-A_ 10u
R56 0 NET0177 205k
C81 0 +3V3 0.1uF
C20 0 +3V3 0.1uF
R24 Net-_D34-K_ NET0138 470
R76 Net-_C10-Pad2_ Net-_C24-Pad1_ 75R
R18 Net-_C65-Pad2_ Net-_C24-Pad1_ 75R
C65 NET0031 Net-_C65-Pad2_ 22nF
C78 0 Net-_C78-Pad2_ 0.1uF
R26 Net-_C31-Pad2_ Net-_C24-Pad1_ 75R
R25 Net-_C12-Pad2_ Net-_C24-Pad1_ 75R
C24 Net-_C24-Pad1_ 0 1nF
C31 NET0154 Net-_C31-Pad2_ 22nF
C12 NET0204 Net-_C12-Pad2_ 22nF
C10 NET0078 Net-_C10-Pad2_ 22nF
C35 Net-_U22-OSC1_ 0 18pF
C71 Net-_U22-OSC2_ 0 18pF
C18 Net-_U32-OSC2_ 0 18pF
C73 0 NET0071 0.1uF
C58 NET0071 0 0.1uF
C7 0 5V_switched_CAN 0.1uF
R70 /NET0053 Net-_R70-Pad2_ 120
C57 0 5V_switched_CAN 0.1uF
R82 /NET0120 Net-_R82-Pad2_ 120
C15 0 NET0071 0.1uF
R74 Net-_U22-_RESET_ NET0071 10k
C42 Net-_U32-OSC1_ 0 18pF
R99 Net-_U32-_RESET_ NET0071 10k
C67 NET0071 0 0.1uF
C13 VMOT 0 47uF
C19 VMOT 0 4.7uF
R29 VMOT /NET0025 100k
C83 VMOT 0 0.1uF
R88 Net-_J23-CC2_ 0 5.1k
R81 0 Net-_J23-CC1_ 5.1k
C69 +5V 0 47uF
C16 VMOT 0 47uF
L2 Net-_D12-K_ +5V 100u
C70 +5V 0 47uF
R22 +5V Net-_Q16-G_ 10k
R35 5V_CAN_ENABLE Net-_JP22-A_ 10k
R67 +3V3 Net-_U24-A_ 10k
R9 +5V Net-_Q6-D_ 10k
R68 Net-_D47-K_ Net-_U16-Y_ 130
R10 NET0040 +3V3 2.2k
R8 +3V3 Net-_U16-Y_ 10k
R43 NET0111 +3V3 2.2k
C17 +3V3 0 0.1uF
C30 +3V3 0 470uF
R36 0 Net-_JP5-B_ 5.1k
C40 3.3V_PI_OUT 0 0.1uF
R16 3.3V_PI_OUT NET0011 10k
R44 3.3V_PI_OUT NET0128 10k
R48 NET0157 /NET0210 27
R33 +3V3 NET0189 10k
C3 +3V3 0 0.1uF
R77 NET0140 /NET0061 27
R27 +3V3 NET0077 10k
R89 +3V3 NET0174 10k
R5 NET0209 Net-_Q5-G_ 100
R13 NET0104 Net-_Q13-G_ 100
R66 NET0023 Net-_Q7-G_ 100
R64 NET0080 Net-_Q1-G_ 100
C49 +5V 0 0.1uF
C80 /NET0027 0 0.1uF
C86 +5V 0 10uF
C56 +5V 0 10uF
R41 VMOT Net-_R4-Pad1_ 50k
R102 Net-_D24-K_ Net-_U24-A_ 130
R45 NET0197 +3V3 2.2k
R54 Net-_D1-K1_ 0 130
R2 Net-_D1-K2_ NET0212 130
R84 /NET0132 +3V3 2.2k
C38 +3V3 0 0.1uF
R75 /NET0073 0 5.1k
R4 Net-_R4-Pad1_ /NET0073 50k
C82 0 +3V3 1uF
R50 +3V3 /NET0105 10k
R72 Net-_D17-K_ /NET0132 130
R49 +3V3 /NET0132 10k

V_12V +12V 0 DC 12.0
V_3V3 +3V3 0 DC 3.3
V_5V +5V 0 DC 5.0

.control
tran 100u 10m
set filetype=ascii
write cm4-robot_raw.raw all
.endc

.end
