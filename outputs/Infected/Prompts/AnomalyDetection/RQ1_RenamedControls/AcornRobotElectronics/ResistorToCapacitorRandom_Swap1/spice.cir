.title KiCad schematic

.model __D41 D

C28 0 Net-_U18-XTAL1_ 22pF
R30 Net-_U18-_RESET_ NET0108 10k
C66 0 NET0108 0.1uF
C24 0 NET0108 0.1uF
C33 Net-_U18-XTAL2_ 0 22pF
C17 0 Net-_U11-XTAL1_ 22pF
C40 Net-_U11-XTAL2_ 0 22pF
R70 Net-_U11-_RESET_ NET0108 10k
R29 NET0199 NET0108 1k
R92 NET0065 NET0108 1k
R60 /NET0001 NET0064 10k
C8 +3V3 0 0.1uF
R37 0 Net-_U35-SDO/SA1_ 5.1k
C47 Net-_U35-C1_ 0 0.1uF
C81 +3V3 0 1uF
C53 +3V3 0 0.1uF
C3 +5V 0 4.7uF
C49 +5V 0 1000uF
R9 NET0064 NET0150 2.2k
R45 +3V3 NET0171 10k
R62 NET0150 0 2.2k
R61 Net-_D39-K_ Net-_D34-A_ 51k
C39 VOUTP 0 47uF
D41 VOUTP Net-_D41-K_ __D41
R51 VOUTN Net-_D39-K_ 249k
R74 Net-_D19-K_ NET0116 470
R78 VOUTN VOUTP 24k
R46 +3V3 Net-_D10-A_ 56
C9 VOUTP VOUTN 0.1uF
R32 0 /NET0154 10k
R96 Net-_D45-K_ Net-_U36-Y_ 1k
R1 +3V3 Net-_D30-A_ 27
C44 5V_switched 0 0.1uF
R48 NET0107 Net-_D6-K_ 1k
R15 0 Net-_D25-K_ 200
C1 5V_switched 0 1uF
C68 +12V 0 1uF
C57 +3V3 0 10uF
C60 +5V 0 10uF
C52 +12V NET0153 22pF
R83 NET0153 +12V 1.8Meg
L3 +5V Net-_D3-A_ 10u
R66 0 NET0153 205k
C23 0 +3V3 0.1uF
C26 0 +3V3 0.1uF
R84 Net-_D23-K_ NET0039 470
R73 Net-_C21-Pad2_ Net-_C75-Pad1_ 75R
R47 Net-_C45-Pad2_ Net-_C75-Pad1_ 75R
C45 NET0035 Net-_C45-Pad2_ 22nF
C16 0 Net-_C16-Pad2_ 0.1uF
R55 Net-_C41-Pad2_ Net-_C75-Pad1_ 75R
R65 Net-_C83-Pad2_ Net-_C75-Pad1_ 75R
C75 Net-_C75-Pad1_ 0 1nF
C41 NET0059 Net-_C41-Pad2_ 22nF
C83 NET0172 Net-_C83-Pad2_ 22nF
C21 NET0100 Net-_C21-Pad2_ 22nF
C29 Net-_U41-OSC1_ 0 18pF
C20 Net-_U41-OSC2_ 0 18pF
C82 Net-_U21-OSC2_ 0 18pF
C46 0 NET0108 0.1uF
C31 NET0108 0 0.1uF
C36 0 5V_switched_CAN 0.1uF
R33 /NET0067 Net-_R33-Pad2_ 120
C12 0 5V_switched_CAN 0.1uF
R14 /NET0027 Net-_R14-Pad2_ 120
C51 0 NET0108 0.1uF
R39 Net-_U41-_RESET_ NET0108 10k
C74 Net-_U21-OSC1_ 0 18pF
R80 Net-_U21-_RESET_ NET0108 10k
C64 NET0108 0 0.1uF
C10 VMOT 0 47uF
C22 VMOT 0 4.7uF
R86 VMOT /NET0032 100k
C50 VMOT 0 0.1uF
R12 Net-_J24-CC2_ 0 5.1k
R85 0 Net-_J24-CC1_ 5.1k
C65 +5V 0 47uF
C85 VMOT 0 47uF
L2 Net-_D2-K_ +5V 100u
C6 +5V 0 47uF
R101 +5V Net-_Q10-G_ 10k
R58 5V_CAN_ENABLE Net-_JP22-A_ 10k
R50 +3V3 Net-_U37-Y_ 10k
R67 +5V Net-_Q11-G_ 10k
R68 Net-_D4-K_ Net-_U19-Y_ 130
R77 NET0109 +3V3 2.2k
R76 +3V3 Net-_U19-Y_ 10k
R100 NET0054 +3V3 2.2k
C14 +3V3 0 0.1uF
C30 +3V3 0 470uF
R89 0 Net-_JP2-B_ 5.1k
C54 3.3V_PI_OUT 0 0.1uF
R7 3.3V_PI_OUT NET0192 10k
R88 3.3V_PI_OUT NET0114 10k
R99 NET0024 /NET0025 27
R10 +3V3 NET0013 10k
C34 +3V3 0 0.1uF
R41 NET0127 /NET0026 27
R19 +3V3 NET0146 10k
R91 +3V3 NET0138 10k
R57 NET0020 Net-_Q5-G_ 100
R27 NET0103 Net-_Q15-G_ 100
R102 NET0007 Net-_Q3-G_ 100
R42 NET0106 Net-_Q2-G_ 100
C63 +5V 0 0.1uF
C58 /NET0165 0 0.1uF
C38 +5V 0 10uF
C67 +5V 0 10uF
R97 VMOT Net-_R38-Pad1_ 50k
R90 Net-_D27-K_ Net-_U37-Y_ 130
R34 NET0156 +3V3 2.2k
R98 Net-_D15-K1_ 0 130
R35 Net-_D15-K2_ NET0021 130
R25 /NET0179 +3V3 2.2k
C25 +3V3 0 0.1uF
R71 /NET0005 0 5.1k
R38 Net-_R38-Pad1_ /NET0005 50k
C86 0 +3V3 1uF
R24 +3V3 /NET0056 10k
R31 Net-_D35-K_ /NET0179 130
R79 +3V3 /NET0179 10k

V_12V +12V 0 DC 12.0
V_3V3 +3V3 0 DC 3.3
V_5V +5V 0 DC 5.0

.control
tran 100u 10m
set filetype=ascii
write cm4-robot_raw.raw all
.endc

.end
