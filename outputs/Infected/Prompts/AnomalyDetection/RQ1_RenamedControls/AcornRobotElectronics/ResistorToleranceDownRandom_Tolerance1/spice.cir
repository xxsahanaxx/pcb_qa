.title KiCad schematic

.model __D1 D

C51 0 Net-_U57-XTAL1_ 22pF
R92 Net-_U57-_RESET_ NET0062 10k
C59 0 NET0062 0.1uF
C8 0 NET0062 0.1uF
C41 Net-_U57-XTAL2_ 0 22pF
C19 0 Net-_U21-XTAL1_ 22pF
C43 Net-_U21-XTAL2_ 0 22pF
R35 Net-_U21-_RESET_ NET0062 10k
R97 NET0091 NET0062 1k
R26 NET0145 NET0062 1k
R100 /NET0083 NET0090 10k
C76 +3V3 0 0.1uF
R50 0 Net-_U52-SDO/SA1_ 5.1k
C68 Net-_U52-C1_ 0 0.1uF
C67 +3V3 0 1uF
C79 +3V3 0 0.1uF
C75 +5V 0 4.7uF
C12 +5V 0 1000uF
R12 NET0090 NET0181 2.2k
R36 +3V3 NET0040 10k
R62 NET0181 0 2.2k
R51 Net-_D17-K_ Net-_D39-A_ 51k
C16 VOUTP 0 47uF
D1 VOUTP Net-_D1-K_ __D1
R23 VOUTN Net-_D17-K_ 249k
R78 Net-_D40-K_ NET0200 470
R48 VOUTN VOUTP 24k
R8 +3V3 Net-_D32-A_ 56
C21 VOUTP VOUTN 0.1uF
R14 0 /NET0138 10k
R47 Net-_D9-K_ Net-_U17-Y_ 1k
R28 +3V3 Net-_D27-A_ 27
C25 5V_switched 0 0.1uF
R52 NET0111 Net-_D33-K_ 1k
R88 0 Net-_D25-K_ 200
C44 5V_switched 0 1uF
C15 +12V 0 1uF
C7 +3V3 0 10uF
C46 +5V 0 10uF
C10 +12V NET0210 22pF
R68 NET0210 +12V 1.8Meg
L3 +5V Net-_D21-A_ 10u
R66 0 NET0210 205k
C84 0 +3V3 0.1uF
C81 0 +3V3 0.1uF
R93 Net-_D20-K_ NET0038 470
R83 Net-_C20-Pad2_ Net-_C30-Pad1_ 75R
R33 Net-_C85-Pad2_ Net-_C30-Pad1_ 75R
C85 NET0129 Net-_C85-Pad2_ 22nF
C73 0 Net-_C73-Pad2_ 0.1uF
R37 Net-_C47-Pad2_ Net-_C30-Pad1_ 75R
R58 Net-_C14-Pad2_ Net-_C30-Pad1_ 75R
C30 Net-_C30-Pad1_ 0 1nF
C47 NET0044 Net-_C47-Pad2_ 22nF
C14 NET0020 Net-_C14-Pad2_ 22nF
C20 NET0183 Net-_C20-Pad2_ 22nF
C48 Net-_U42-OSC1_ 0 18pF
C64 Net-_U42-OSC2_ 0 18pF
C32 Net-_U32-OSC2_ 0 18pF
C4 0 NET0062 0.1uF
C45 NET0062 0 0.1uF
C27 0 5V_switched_CAN 0.1uF
R54 /NET0136 Net-_R54-Pad2_ 120
C82 0 5V_switched_CAN 0.1uF
R9 /NET0201 Net-_R9-Pad2_ 120
C18 0 NET0062 0.1uF
R2 Net-_U42-_RESET_ NET0062 10k
C74 Net-_U32-OSC1_ 0 18pF
R73 Net-_U32-_RESET_ NET0062 10k
C23 NET0062 0 0.1uF
C34 VMOT 0 47uF
C3 VMOT 0 4.7uF
R43 VMOT /NET0114 100k
C78 VMOT 0 0.1uF
R76 Net-_J27-CC2_ 0 5.1k
R84 0 Net-_J27-CC1_ 5.1k
C40 +5V 0 47uF
C5 VMOT 0 47uF
L2 Net-_D36-K_ +5V 100u
C63 +5V 0 47uF
R6 +5V Net-_Q10-G_ 10k
R87 5V_CAN_ENABLE Net-_JP4-A_ 10k
R7 +3V3 Net-_U11-A_ 10k
R13 +5V Net-_Q14-G_ 10k
R21 Net-_D23-K_ Net-_U24-Y_ 130
R24 NET0054 +3V3 2.2k
R70 +3V3 Net-_U24-Y_ 10k
R57 NET0014 +3V3 2.2k
C80 +3V3 0 0.1uF
C62 +3V3 0 470uF
R75 0 Net-_JP1-B_ 5.1k
R4 NET0132 /NET0012 27
R71 +3V3 NET0179 10k
C70 +3V3 0 0.1uF
R81 NET0123 /NET0211 27
R19 +3V3 NET0078 10k
R44 NET0095 Net-_Q15-G_ 100
R59 NET0106 Net-_Q5-G_ 100
R53 NET0011 Net-_Q16-G_ 100
R41 NET0052 Net-_Q12-G_ 100
R82 +3V3 NET0088 10k
C71 3.3V_PI_OUT 0 0.1uF
R31 3.3V_PI_OUT NET0065 10k
R40 3.3V_PI_OUT NET0122 10k
C29 +5V 0 0.1uF
C49 /NET0026 0 0.1uF
C58 +5V 0 10uF
C57 +5V 0 10uF
R72 VMOT Net-_R63-Pad1_ 50k
R20 Net-_D22-K_ Net-_U11-A_ 130
R38 NET0176 +3V3 2.2k
R49 Net-_D38-K1_ 0 130
R42 Net-_D38-K2_ NET0146 130
R1 /NET0005 +3V3 2.2k
C61 +3V3 0 0.1uF
R101 /NET0117 0 5.1k
R63 Net-_R63-Pad1_ /NET0117 50k
C11 0 +3V3 1uF
R30 +3V3 /NET0041 10k
R29 Net-_D31-K_ /NET0005 130
R18 +3V3 /NET0005 10k

V_12V +12V 0 DC 12.0
V_3V3 +3V3 0 DC 3.3
V_5V +5V 0 DC 5.0

.control
tran 100u 10m
set filetype=ascii
write cm4-robot_raw.raw all
.endc

.end
