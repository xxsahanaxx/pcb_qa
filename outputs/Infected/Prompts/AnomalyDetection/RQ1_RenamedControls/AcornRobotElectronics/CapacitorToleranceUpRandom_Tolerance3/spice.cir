.title KiCad schematic

.model __D11 D

C73 0 Net-_U4-XTAL1_ 22pF
R52 Net-_U4-_RESET_ NET0037 10k
C37 0 NET0037 0.1uF
C86 0 NET0037 0.1uF
C63 Net-_U4-XTAL2_ 0 22pF
C68 0 Net-_U53-XTAL1_ 22pF
C82 Net-_U53-XTAL2_ 0 22pF
R41 Net-_U53-_RESET_ NET0037 10k
R87 NET0181 NET0037 1k
R36 NET0062 NET0037 1k
R45 /NET0017 NET0187 10k
C29 +3V3 0 0.1uF
R55 0 Net-_U36-SDO/SA1_ 5.1k
C33 Net-_U36-C1_ 0 0.1uF
C1 +3V3 0 1uF
C12 +3V3 0 0.1uF
C3 +5V 0 4.7uF
C44 +5V 0 1000uF
R82 NET0187 NET0105 2.2k
R3 +3V3 NET0153 10k
R12 NET0105 0 2.2k
R77 Net-_D38-K_ Net-_D23-A_ 51k
C76 VOUTP 0 47uF
D11 VOUTP Net-_D11-K_ __D11
R80 VOUTN Net-_D38-K_ 249k
R68 Net-_D7-K_ NET0156 470
R85 VOUTN VOUTP 24k
R75 +3V3 Net-_D1-A_ 56
C21 VOUTP VOUTN 0.1uF
R33 0 /NET0087 10k
R58 Net-_D15-K_ Net-_U44-Y_ 1k
R6 +3V3 Net-_D20-A_ 27
C78 5V_switched 0 0.1uF
R96 NET0174 Net-_D6-K_ 1k
R37 0 Net-_D34-K_ 200
C14 5V_switched 0 1uF
C24 +12V 0 1uF
C43 +3V3 0 10uF
C6 +5V 0 10uF
C64 +12V NET0196 22pF
R81 NET0196 +12V 1.8Meg
L1 +5V Net-_D45-A_ 10u
R101 0 NET0196 205k
C48 0 +3V3 0.1uF
C71 0 +3V3 0.1uF
R71 Net-_D3-K_ NET0064 470
R50 Net-_C81-Pad2_ Net-_C74-Pad1_ 75R
R79 Net-_C42-Pad2_ Net-_C74-Pad1_ 75R
C42 NET0079 Net-_C42-Pad2_ 22nF
C10 0 Net-_C10-Pad2_ 0.1uF
R74 Net-_C65-Pad2_ Net-_C74-Pad1_ 75R
R70 Net-_C58-Pad2_ Net-_C74-Pad1_ 75R
C74 Net-_C74-Pad1_ 0 1nF
C65 NET0184 Net-_C65-Pad2_ 22nF
C58 NET0164 Net-_C58-Pad2_ 22nF
C81 NET0198 Net-_C81-Pad2_ 22nF
C20 Net-_U49-OSC1_ 0 18pF
C54 Net-_U49-OSC2_ 0 18pF
C57 Net-_U35-OSC2_ 0 18pF
C4 0 NET0037 0.1uF
C31 NET0037 0 0.1uF
C59 0 5V_switched_CAN 0.1uF
R35 /NET0101 Net-_R35-Pad2_ 120
C38 0 5V_switched_CAN 0.1uF
R93 /NET0145 Net-_R93-Pad2_ 120
C2 0 NET0037 0.1uF
R73 Net-_U49-_RESET_ NET0037 10k
C49 Net-_U35-OSC1_ 0 18pF
R16 Net-_U35-_RESET_ NET0037 10k
C79 NET0037 0 0.1uF
C27 VMOT 0 47uF
C46 VMOT 0 4.7uF
R61 VMOT /NET0076 100k
C9 VMOT 0 0.1uF
R67 Net-_J22-CC2_ 0 5.1k
R13 0 Net-_J22-CC1_ 5.1k
C13 +5V 0 47uF
C61 VMOT 0 47uF
L3 Net-_D28-K_ +5V 100u
C19 +5V 0 47uF
R17 +5V Net-_Q10-G_ 10k
R92 5V_CAN_ENABLE Net-_JP23-A_ 10k
R88 +3V3 Net-_U1-Y_ 10k
R46 +5V Net-_Q6-D_ 10k
R66 Net-_D31-K_ Net-_U1-A_ 130
R44 NET0011 +3V3 2.2k
R53 +3V3 Net-_U1-A_ 10k
R1 NET0178 +3V3 2.2k
C11 +3V3 0 0.1uF
C72 +3V3 0 470uF
R22 0 Net-_JP1-B_ 5.1k
R62 NET0133 /NET0086 27
R28 +3V3 NET0068 10k
C45 +3V3 0 0.1uF
R91 NET0159 /NET0209 27
R21 +3V3 NET0083 10k
R29 NET0007 Net-_Q14-G_ 100
R40 NET0126 Net-_Q4-G_ 100
R9 NET0146 Net-_Q13-G_ 100
R47 NET0154 Net-_Q15-G_ 100
R83 +3V3 NET0125 10k
C84 3.3V_PI_OUT 0 0.1uF
R72 3.3V_PI_OUT NET0098 10k
R84 3.3V_PI_OUT NET0071 10k
C15 +5V 0 0.1uF
C26 /NET0045 0 0.1uF
C7 +5V 0 10uF
C85 +5V 0 10uF
R97 VMOT Net-_R69-Pad1_ 50k
R56 Net-_D35-K_ Net-_U1-Y_ 130
R95 NET0033 +3V3 2.2k
R32 Net-_D17-K1_ 0 130
R90 Net-_D17-K2_ NET0185 130
R49 /NET0203 +3V3 2.2k
C55 +3V3 0 0.1uF
R5 /NET0026 0 5.1k
R69 Net-_R69-Pad1_ /NET0026 50k
C36 0 +3V3 1uF
R102 +3V3 /NET0121 10k
R15 Net-_D42-K_ /NET0203 130
R4 +3V3 /NET0203 10k

V_12V +12V 0 DC 12.0
V_3V3 +3V3 0 DC 3.3
V_5V +5V 0 DC 5.0

.control
tran 100u 10m
set filetype=ascii
write cm4-robot_raw.raw all
.endc

.end
