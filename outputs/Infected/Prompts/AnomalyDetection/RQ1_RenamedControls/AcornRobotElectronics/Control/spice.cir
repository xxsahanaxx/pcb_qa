.title KiCad schematic

.model __D13 D

C44 0 Net-_U7-XTAL1_ 22pF
R64 Net-_U7-_RESET_ NET0046 10k
C83 0 NET0046 0.1uF
C53 0 NET0046 0.1uF
C76 Net-_U7-XTAL2_ 0 22pF
C72 0 Net-_U50-XTAL1_ 22pF
C38 Net-_U50-XTAL2_ 0 22pF
R92 Net-_U50-_RESET_ NET0046 10k
R31 NET0086 NET0046 1k
R74 NET0043 NET0046 1k
R16 /NET0063 NET0007 10k
C46 +3V3 0 0.1uF
R51 0 Net-_U54-SDO/SA1_ 5.1k
C26 Net-_U54-C1_ 0 0.1uF
C86 +3V3 0 1uF
C2 +3V3 0 0.1uF
C43 +5V 0 4.7uF
C19 +5V 0 1000uF
R44 NET0007 NET0147 2.2k
R21 +3V3 NET0144 10k
R48 NET0147 0 2.2k
R41 Net-_D45-K_ Net-_D6-A_ 51k
C81 VOUTP 0 47uF
D13 VOUTP Net-_D13-K_ __D13
R85 VOUTN Net-_D45-K_ 249k
R27 Net-_D25-K_ NET0080 470
R15 VOUTN VOUTP 24k
R52 +3V3 Net-_D31-A_ 56
C54 VOUTP VOUTN 0.1uF
R11 0 /NET0055 10k
R81 Net-_D28-K_ Net-_U57-Y_ 1k
R49 +3V3 Net-_D49-A_ 27
C64 5V_switched 0 0.1uF
R46 NET0137 Net-_D27-K_ 1k
R25 0 Net-_D30-K_ 200
C39 5V_switched 0 1uF
C32 +12V 0 1uF
C60 +3V3 0 10uF
C3 +5V 0 10uF
C52 +12V NET0203 22pF
R68 NET0203 +12V 1.8Meg
L3 +5V Net-_D22-A_ 10u
R89 0 NET0203 205k
C68 0 +3V3 0.1uF
C18 0 +3V3 0.1uF
R61 Net-_D26-K_ NET0049 470
R45 Net-_C28-Pad2_ Net-_C25-Pad1_ 75R
R57 Net-_C71-Pad2_ Net-_C25-Pad1_ 75R
C71 NET0213 Net-_C71-Pad2_ 22nF
C5 0 Net-_C5-Pad2_ 0.1uF
R70 Net-_C12-Pad2_ Net-_C25-Pad1_ 75R
R88 Net-_C62-Pad2_ Net-_C25-Pad1_ 75R
C25 Net-_C25-Pad1_ 0 1nF
C12 NET0067 Net-_C12-Pad2_ 22nF
C62 NET0182 Net-_C62-Pad2_ 22nF
C28 NET0082 Net-_C28-Pad2_ 22nF
C33 Net-_U41-OSC1_ 0 18pF
C67 Net-_U41-OSC2_ 0 18pF
C15 Net-_U38-OSC2_ 0 18pF
C56 0 NET0046 0.1uF
C20 NET0046 0 0.1uF
C47 0 5V_switched_CAN 0.1uF
R2 /NET0016 Net-_R2-Pad2_ 120
C11 0 5V_switched_CAN 0.1uF
R26 /NET0141 Net-_R26-Pad2_ 120
C13 0 NET0046 0.1uF
R1 Net-_U41-_RESET_ NET0046 10k
C4 Net-_U38-OSC1_ 0 18pF
R79 Net-_U38-_RESET_ NET0046 10k
C23 NET0046 0 0.1uF
C48 VMOT 0 47uF
C79 VMOT 0 4.7uF
R13 VMOT /NET0138 100k
C50 VMOT 0 0.1uF
R53 Net-_J28-CC2_ 0 5.1k
R30 0 Net-_J28-CC1_ 5.1k
C37 +5V 0 47uF
C14 VMOT 0 47uF
L2 Net-_D5-K_ +5V 100u
C66 +5V 0 47uF
R3 +5V Net-_Q12-G_ 10k
R98 5V_CAN_ENABLE Net-_JP22-A_ 10k
R69 +3V3 Net-_U20-Y_ 10k
R77 +5V Net-_Q15-D_ 10k
R78 Net-_D37-K_ Net-_U20-A_ 130
R94 NET0094 +3V3 2.2k
R42 +3V3 Net-_U20-A_ 10k
R91 NET0188 +3V3 2.2k
C73 +3V3 0 0.1uF
C57 +3V3 0 470uF
R5 0 Net-_JP13-B_ 5.1k
R54 NET0181 /NET0090 27
R71 +3V3 NET0155 10k
C77 +3V3 0 0.1uF
R23 NET0009 /NET0078 27
R75 +3V3 NET0034 10k
R59 NET0198 Net-_Q8-G_ 100
R7 NET0156 Net-_Q6-G_ 100
R24 NET0209 Net-_Q11-G_ 100
R73 NET0113 Net-_Q2-G_ 100
R18 +3V3 NET0085 10k
C80 3.3V_PI_OUT 0 0.1uF
R82 3.3V_PI_OUT NET0163 10k
R66 3.3V_PI_OUT NET0070 10k
C59 +5V 0 0.1uF
C16 /NET0196 0 0.1uF
C21 +5V 0 10uF
C41 +5V 0 10uF
R29 VMOT Net-_R29-Pad2_ 50k
R84 Net-_D21-K_ Net-_U20-Y_ 130
R39 NET0068 +3V3 2.2k
R93 Net-_D33-K1_ 0 130
R12 Net-_D33-K2_ NET0199 130
R37 /NET0100 +3V3 2.2k
C75 +3V3 0 0.1uF
R32 /NET0125 0 5.1k
R97 Net-_R29-Pad2_ /NET0125 50k
C1 0 +3V3 1uF
R22 +3V3 /NET0212 10k
R100 Net-_D24-K_ /NET0100 130
R8 +3V3 /NET0100 10k

V_12V +12V 0 DC 12.0
V_3V3 +3V3 0 DC 3.3
V_5V +5V 0 DC 5.0

.control
tran 100u 10m
set filetype=ascii
write cm4-robot_raw.raw all
.endc

.end
