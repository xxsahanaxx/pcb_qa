.title KiCad schematic

.model __D9 D

C30 0 Net-_U26-XTAL1_ 22pF
R79 Net-_U26-_RESET_ NET0196 10k
C9 0 NET0196 0.1uF
C52 0 NET0196 0.1uF
C69 Net-_U26-XTAL2_ 0 22pF
C41 0 Net-_U13-XTAL1_ 22pF
C76 Net-_U13-XTAL2_ 0 22pF
R96 Net-_U13-_RESET_ NET0196 10k
R13 NET0101 NET0196 1k
R60 NET0051 NET0196 1k
R43 /NET0130 NET0191 10k
C45 +3V3 0 0.1uF
R84 0 Net-_U47-SDO/SA1_ 5.1k
C55 Net-_U47-C1_ 0 0.1uF
C1 +3V3 0 1uF
C15 +3V3 0 0.1uF
C85 +5V 0 4.7uF
C50 +5V 0 1000uF
R90 NET0191 NET0120 2.2k
R94 +3V3 NET0154 10k
R33 NET0120 0 2.2k
R50 Net-_D15-K_ Net-_D32-A_ 51k
C33 VOUTP 0 47uF
D9 VOUTP Net-_D9-K_ __D9
R42 VOUTN Net-_D15-K_ 249k
R101 Net-_D45-K_ NET0020 470
R82 VOUTN VOUTP 24k
R45 +3V3 Net-_D49-A_ 56
C54 VOUTP VOUTN 0.1uF
R10 0 /NET0022 10k
R63 Net-_D30-K_ Net-_U24-Y_ 1k
R74 +3V3 Net-_D22-A_ 27
C12 5V_switched 0 0.1uF
R38 NET0203 Net-_D31-K_ 1k
R16 0 Net-_D7-K_ 200
C34 5V_switched 0 1uF
C66 +12V 0 1uF
C38 +3V3 0 10uF
C16 +5V 0 10uF
C47 +12V NET0131 22pF
R59 NET0131 +12V 1.8Meg
L1 +5V Net-_D29-A_ 10u
R98 0 NET0131 205k
C68 0 +3V3 0.1uF
C64 0 +3V3 0.1uF
R31 Net-_D40-K_ NET0137 470
R66 Net-_C57-Pad2_ Net-_C71-Pad1_ 75R
R68 Net-_C37-Pad2_ Net-_C71-Pad1_ 75R
C37 NET0145 Net-_C37-Pad2_ 22nF
C43 0 Net-_C43-Pad2_ 0.1uF
R22 Net-_C11-Pad2_ Net-_C71-Pad1_ 75R
R70 Net-_C14-Pad2_ Net-_C71-Pad1_ 75R
C71 Net-_C71-Pad1_ 0 1nF
C11 NET0116 Net-_C11-Pad2_ 22nF
C14 NET0034 Net-_C14-Pad2_ 22nF
C57 NET0199 Net-_C57-Pad2_ 22nF
C42 Net-_U57-OSC1_ 0 18pF
C62 Net-_U57-OSC2_ 0 18pF
C67 Net-_U40-OSC2_ 0 18pF
C70 0 NET0196 0.1uF
C59 NET0196 0 0.1uF
C78 0 5V_switched_CAN 0.1uF
R81 /NET0214 Net-_R81-Pad2_ 120
C32 0 5V_switched_CAN 0.1uF
R62 /NET0055 Net-_R62-Pad2_ 120
C2 0 NET0196 0.1uF
R73 Net-_U57-_RESET_ NET0196 10k
C51 Net-_U40-OSC1_ 0 18pF
R93 Net-_U40-_RESET_ NET0196 10k
C7 NET0196 0 0.1uF
C26 VMOT 0 47uF
C13 VMOT 0 4.7uF
R100 VMOT /NET0083 100k
C29 VMOT 0 0.1uF
R25 Net-_J33-CC2_ 0 5.1k
R97 0 Net-_J33-CC1_ 5.1k
C27 +5V 0 47uF
C84 VMOT 0 47uF
L3 Net-_D42-K_ +5V 100u
C19 +5V 0 47uF
R49 +5V Net-_Q15-G_ 10k
R41 5V_CAN_ENABLE Net-_JP9-A_ 10k
R27 +3V3 Net-_U12-A_ 10k
R4 +5V Net-_Q16-G_ 10k
R83 Net-_D2-K_ Net-_U38-Y_ 130
R92 NET0150 +3V3 2.2k
R46 +3V3 Net-_U38-Y_ 10k
R29 NET0197 +3V3 2.2k
C81 +3V3 0 0.1uF
C28 +3V3 0 470uF
R85 0 Net-_JP16-B_ 5.1k
R34 NET0042 /NET0163 27
R9 +3V3 NET0201 10k
C83 +3V3 0 0.1uF
R54 NET0082 /NET0190 27
R24 +3V3 NET0087 10k
R40 NET0134 Net-_Q4-G_ 100
R87 NET0052 Net-_Q9-G_ 100
R65 NET0044 Net-_Q12-G_ 100
R20 NET0187 Net-_Q11-G_ 100
R67 +3V3 NET0121 10k
C49 3.3V_PI_OUT 0 0.1uF
R72 3.3V_PI_OUT NET0028 10k
R3 3.3V_PI_OUT NET0029 10k
C25 +5V 0 0.1uF
C61 /NET0115 0 0.1uF
C4 +5V 0 10uF
C10 +5V 0 10uF
R11 VMOT Net-_R11-Pad2_ 50k
R2 Net-_D16-K_ Net-_U12-A_ 130
R78 NET0110 +3V3 2.2k
R1 Net-_D37-K1_ 0 130
R89 Net-_D37-K2_ NET0009 130
R15 /NET0142 +3V3 2.2k
C23 +3V3 0 0.1uF
R44 /NET0210 0 5.1k
R75 Net-_R11-Pad2_ /NET0210 50k
C40 0 +3V3 1uF
R47 +3V3 /NET0038 10k
R102 Net-_D3-K_ /NET0142 130
R86 +3V3 /NET0142 10k

V_12V +12V 0 DC 12.0
V_3V3 +3V3 0 DC 3.3
V_5V +5V 0 DC 5.0

.control
tran 100u 10m
set filetype=ascii
write cm4-robot_raw.raw all
.endc

.end
