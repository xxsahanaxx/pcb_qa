.title KiCad schematic

.model __D45 D

C75 0 Net-_U46-XTAL1_ 22pF
R94 Net-_U46-_RESET_ NET0019 10k
C84 0 NET0019 0.1uF
C50 0 NET0019 0.1uF
C26 Net-_U46-XTAL2_ 0 22pF
C83 0 Net-_U52-XTAL1_ 22pF
C51 Net-_U52-XTAL2_ 0 22pF
R37 Net-_U52-_RESET_ NET0019 10k
R36 NET0032 NET0019 1k
R21 NET0164 NET0019 1k
R6 /NET0002 NET0039 10k
C22 +3V3 0 0.1uF
R98 0 Net-_U18-SDO/SA1_ 5.1k
C63 Net-_U18-C1_ 0 0.1uF
C15 +3V3 0 1uF
C52 +3V3 0 0.1uF
C14 +5V 0 4.7uF
C49 +5V 0 1000uF
R25 NET0039 NET0152 2.2k
R84 +3V3 NET0210 10k
R17 NET0152 0 2.2k
R95 Net-_D24-K_ Net-_D46-A_ 51k
C46 VOUTP 0 47uF
D45 VOUTP Net-_D45-K_ __D45
R11 VOUTN Net-_D24-K_ 249k
R41 Net-_D29-K_ NET0176 470
R92 VOUTN VOUTP 24k
R79 +3V3 Net-_D2-A_ 56
C80 VOUTP VOUTN 0.1uF
R4 0 /NET0088 10k
R27 Net-_D6-K_ Net-_U31-Y_ 1k
R33 +3V3 Net-_D10-A_ 27
C17 5V_switched 0 0.1uF
R5 NET0207 Net-_D22-K_ 1k
R48 0 Net-_D15-K_ 200
C11 5V_switched 0 1uF
C25 +12V 0 1uF
C38 +3V3 0 10uF
C62 +5V 0 10uF
C71 +12V NET0136 22pF
R56 NET0136 +12V 1.8Meg
L3 +5V Net-_D44-A_ 10u
R93 0 NET0136 205k
C16 0 +3V3 0.1uF
C73 0 +3V3 0.1uF
R81 Net-_D19-K_ NET0106 470
R66 Net-_C1-Pad2_ Net-_C45-Pad1_ 75R
R30 Net-_C27-Pad2_ Net-_C45-Pad1_ 75R
C27 NET0015 Net-_C27-Pad2_ 22nF
C48 0 Net-_C48-Pad2_ 0.1uF
R40 Net-_C66-Pad2_ Net-_C45-Pad1_ 75R
R83 Net-_C2-Pad2_ Net-_C45-Pad1_ 75R
C45 Net-_C45-Pad1_ 0 1nF
C66 NET0211 Net-_C66-Pad2_ 22nF
C2 NET0156 Net-_C2-Pad2_ 22nF
C1 NET0177 Net-_C1-Pad2_ 22nF
C39 Net-_U47-OSC1_ 0 18pF
C36 Net-_U47-OSC2_ 0 18pF
C24 Net-_U16-OSC2_ 0 18pF
C43 0 NET0019 0.1uF
C47 NET0019 0 0.1uF
C53 0 5V_switched_CAN 0.1uF
R13 /NET0204 Net-_R13-Pad2_ 120
C33 0 5V_switched_CAN 0.1uF
R90 /NET0036 Net-_R90-Pad2_ 120
C9 0 NET0019 0.1uF
R74 Net-_U47-_RESET_ NET0019 10k
C55 Net-_U16-OSC1_ 0 18pF
R3 Net-_U16-_RESET_ NET0019 10k
C81 NET0019 0 0.1uF
C12 VMOT 0 47uF
C69 VMOT 0 4.7uF
R78 VMOT /NET0142 100k
C70 VMOT 0 0.1uF
R46 Net-_J11-CC2_ 0 5.1k
R44 0 Net-_J11-CC1_ 5.1k
C32 +5V 0 47uF
C7 VMOT 0 47uF
L2 Net-_D49-K_ +5V 100u
C54 +5V 0 47uF
R73 +5V Net-_Q10-G_ 10k
R96 5V_CAN_ENABLE Net-_JP1-A_ 10k
R68 +3V3 Net-_U10-Y_ 10k
R102 +5V Net-_Q11-G_ 10k
R59 Net-_D3-K_ Net-_U10-A_ 130
R63 NET0065 +3V3 2.2k
R55 +3V3 Net-_U10-A_ 10k
R58 NET0121 +3V3 2.2k
C35 +3V3 0 0.1uF
C37 +3V3 0 470uF
R60 0 Net-_JP4-B_ 5.1k
C57 3.3V_PI_OUT 0 0.1uF
R7 3.3V_PI_OUT NET0185 10k
R91 3.3V_PI_OUT NET0181 10k
R15 NET0202 /NET0144 27
R29 +3V3 NET0145 10k
C68 +3V3 0 0.1uF
R50 NET0008 /NET0203 27
R54 +3V3 NET0027 10k
R35 +3V3 NET0122 10k
R97 NET0010 Net-_Q15-G_ 100
R87 NET0038 Net-_Q13-G_ 100
R100 NET0094 Net-_Q5-G_ 100
R26 NET0115 Net-_Q12-G_ 100
C42 +5V 0 0.1uF
C13 /NET0104 0 0.1uF
C61 +5V 0 10uF
C19 +5V 0 10uF
R9 VMOT Net-_R53-Pad1_ 50k
R67 Net-_D36-K_ Net-_U10-Y_ 130
R19 NET0073 +3V3 2.2k
R12 Net-_D38-K1_ 0 130
R70 Net-_D38-K2_ NET0017 130
R72 /NET0151 +3V3 2.2k
C34 +3V3 0 0.1uF
R77 /NET0107 0 5.1k
R53 Net-_R53-Pad1_ /NET0107 50k
C76 0 +3V3 1uF
R88 +3V3 /NET0009 10k
R49 Net-_D13-K_ /NET0151 130
R61 +3V3 /NET0151 10k

V_12V +12V 0 DC 12.0
V_3V3 +3V3 0 DC 3.3
V_5V +5V 0 DC 5.0

.control
tran 100u 10m
set filetype=ascii
write cm4-robot_raw.raw all
.endc

.end
