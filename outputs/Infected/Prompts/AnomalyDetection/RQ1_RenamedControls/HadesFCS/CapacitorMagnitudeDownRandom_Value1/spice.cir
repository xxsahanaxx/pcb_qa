.title KiCad schematic

.model LED_D_G D (Is=1p Rs=10 N=1.7)
.model LED_D_B D (Is=1p Rs=10 N=1.7)
.model LED_D_Y D (Is=1p Rs=10 N=1.7)
.model LED_D_R D (Is=1p Rs=10 N=1.7)

R12 NET0101 VIN+ 0.01
C8 +3.3V 0 100n
C5 +5V NET0007 4.7n
L2 NET0013 +5V 15u
R75 +5V NET0007 6.8k
C6 +5V 0 47u
C91 +5V 0 100u
C11 NET0013 Net-_C11-Pad2_ 100n
R3 0 NET0007 1.3k
R39 Net-_C11-Pad2_ NET0007 19.6k
C47 NET0013 NET0081 100n
DLED14 Net-_LED14-K_ +5V LED_D_G
R45 0 Net-_LED14-K_ 560
R93 NET0155 Net-_D3-A_ 10k
C20 Net-_D3-A_ 0 2.2u
C55 Net-_REG2-PVDD_ 0 2.2u
R37 NET0101 NET0017 10k
C49 NET0101 0 100u
C43 NET0101 0 47u
R69 0 Net-_LED15-K_ 240
DLED15 Net-_LED15-K_ +3.3V LED_D_G
C106 +5V 0 10u
C111 +3.3V 0 10u
C45 NET0170 0 10p
C88 Net-_C88-Pad1_ 0 10p
R29 NET0159 Net-_C88-Pad1_ 620
C99 +3V3 0 100n
R51 +3V3 NET0040 4.7k
R58 +3V3 NET0177 4.7k
R7 +3V3 NET0062 4.7k
C109 +3V3 0 100n
C73 +3V3 0 100n
C90 +3V3 0 100n
R43 +3V3 NET0009 4.7k
R91 +3V3 NET0120 4.7k
R6 +3V3 NET0011 4.7k
C75 +3V3 0 100n
C38 +3V3 0 100n
DLED20 Net-_LED20-K_ NET0028 LED_D_B
R76 0 Net-_LED20-K_ 100
C65 VREF+_FCC 0 100n
R89 VREF+_FCC VDDA_FCC 47
C26 VDDA_FCC 0 100n
R50 0 Net-_LED10-K_ 330
R81 0 Net-_LED1-K_ 330
DLED6 Net-_LED6-K_ NET0076 LED_D_B
R54 0 Net-_LED6-K_ 100
C84 NET0084 0 100n
R15 0 Net-_LED11-K_ 330
DLED7 Net-_LED7-K_ NET0073 LED_D_B
DLED11 Net-_LED11-K_ NET0128 LED_D_Y
R48 0 Net-_LED7-K_ 100
DLED10 Net-_LED10-K_ NET0129 LED_D_R
DLED1 Net-_LED1-K_ NET0095 LED_D_R
C61 +3V3 0 100n
C17 +3V3 0 100n
C76 +3V3 0 100n
C51 +3V3 0 100n
C59 +3V3 0 100n
C18 Net-_FCC2-PH0_ 0 2.2u
C23 unconnected-_C23-Pad1_ 0 2.2u
R42 Net-_SW8-C_ NET0037 10k
R80 NET0065 Net-_C83-Pad1_ 620
C83 Net-_C83-Pad1_ 0 10p
C2 NET0074 0 10p
R70 +3V3 NET0038 4.7k
R16 +3V3 NET0014 4.7k
R2 +3V3 NET0146 4.7k
R1 +3V3 NET0029 4.7k
DLED18 Net-_LED18-K_ NET0026 LED_D_Y
DLED17 Net-_LED17-K_ NET0144 LED_D_B
R46 0 Net-_LED18-K_ 330
R27 0 Net-_LED17-K_ 100
DLED13 Net-_LED13-K_ NET0131 LED_D_R
R66 0 Net-_LED13-K_ 330
DLED16 Net-_LED16-K_ NET0089 LED_D_R
R71 0 Net-_LED16-K_ 330
C27 Net-_NAVC2-PH1_ 0 2.2u
C50 Net-_NAVC2-PH0_ 0 2.2u
C101 +3V3 0 100n
C29 +3V3 0 100n
C74 VDDA_NAVC 0 100n
C66 +3V3 0 100n
C3 +3V3 0 100n
C21 +3V3 0 100n
C25 +3V3 0 100n
C68 +3V3 0 100n
C36 +3V3 0 100n
C72 +3V3 0 100n
R82 Net-_SW7-C_ NET0138 10k
C44 NET0149 0 100n
R26 Net-_SW5-C_ NET0025 10k
R8 NET0104 NET0018 10
R21 NET0175 NET0139 10
R31 NET0031 NET0117 10
R30 NET0088 NET0034 10
R11 NET0061 NET0147 10
R88 NET0167 NET0041 10
R77 NET0151 NET0106 10
R5 NET0134 NET0153 10
R74 NET0068 Net-_USB6-D-_ 22
R18 NET0005 Net-_USB6-ID_ 560
R72 NET0150 Net-_USB6-D+_ 22
R67 NET0109 Net-_USB3-D+_ 22
R55 NET0030 Net-_USB3-D-_ 22
R63 NET0021 Net-_USB3-ID_ 560
DLED12 Net-_LED12-K_ Net-_D6-A_ LED_D_G
R41 0 Net-_LED12-K_ 560
C19 0 Net-_D6-A_ 100n
R61 0 Net-_LED22-K_ 560
DLED22 Net-_LED22-K_ Net-_D2-A_ LED_D_G
C10 0 Net-_D2-A_ 100n
R20 NET0058 NET0120 0
R52 NET0087 NET0011 0
R53 NET0001 NET0054 10
R33 NET0161 NET0165 10
C53 0 unconnected-_C53-Pad2_ 100n
C108 0 unconnected-_C108-Pad2_ 100n
C4 +3.3V 0 100n
R94 +3.3V Net-_U8-_WP__IO2__ 10k
R86 +3.3V Net-_U8-_HOLD__IO3__ 10k
C81 0 +3.3V 100n
C112 +3.3V 0 100n
C96 +3.3V 0 100n
C48 +3.3V 0 100n
C79 +3.3V 0 1u
C102 +3.3V 0 1u
C62 +3.3V 0 100n
C82 +3.3V 0 100n
C42 Net-_U15-C1_ 0 220n
R4 +3.3V NET0110 10k
C12 +3.3V 0 10u
R23 Net-_L3-Pad1_ Net-_U12-VCC_RF_ 10
C39 Net-_ANT2-Pad1_ Net-_U12-RF_IN_ 22p
C64 Net-_ANT2-Pad1_ 0 10n
L3 Net-_L3-Pad1_ Net-_ANT2-Pad1_ 27n
C105 +3.3V 0 100n
C67 +3.3V 0 100n
C33 Net-_U3-VO-_ Net-_U3-VO+_ 1n
C113 +3.3V 0 100n
R9 +3.3V NET0078 10k

V_3_3V +3.3V 0 DC 3.3
V_3V3 +3V3 0 DC 3.3
V_5V +5V 0 DC 5.0

.control
tran 100u 10m
set filetype=ascii
write Hades_raw.raw all
.endc

.end
