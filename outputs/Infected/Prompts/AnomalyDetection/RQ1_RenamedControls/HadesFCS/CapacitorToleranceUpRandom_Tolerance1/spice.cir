.title KiCad schematic

.model LED_D_G D (Is=1p Rs=10 N=1.7)
.model LED_D_B D (Is=1p Rs=10 N=1.7)
.model LED_D_Y D (Is=1p Rs=10 N=1.7)
.model LED_D_R D (Is=1p Rs=10 N=1.7)

R46 NET0019 VIN+ 0.01
C94 +3.3V 0 100n
C72 +5V NET0006 4.7n
L2 NET0009 +5V 15u
R20 +5V NET0006 6.8k
C85 +5V 0 47u
C89 +5V 0 100u
C69 NET0009 Net-_C69-Pad2_ 100n
R63 0 NET0006 1.3k
R43 Net-_C69-Pad2_ NET0006 19.6k
C30 NET0009 NET0126 100n
DLED2 Net-_LED2-K_ +5V LED_D_G
R21 0 Net-_LED2-K_ 560
R53 NET0140 Net-_D5-A_ 10k
C38 Net-_D5-A_ 0 2.2u
C18 Net-_REG2-PVDD_ 0 2.2u
R88 NET0019 NET0044 10k
C107 NET0019 0 100u
C42 NET0019 0 47u
R90 0 Net-_LED15-K_ 240
DLED15 Net-_LED15-K_ +3.3V LED_D_G
C87 +5V 0 10u
C101 +3.3V 0 10u
C21 NET0089 0 10p
C54 Net-_C54-Pad1_ 0 10p
R32 NET0029 Net-_C54-Pad1_ 620
C62 +3V3 0 100n
C93 +3V3 0 100n
R92 +3V3 NET0164 4.7k
R72 +3V3 NET0011 4.7k
R44 +3V3 NET0158 4.7k
R83 +3V3 NET0172 4.7k
C108 +3V3 0 100n
C86 +3V3 0 100n
DLED13 Net-_LED13-K_ NET0143 LED_D_B
R33 0 Net-_LED13-K_ 100
R77 +3V3 NET0025 4.7k
R3 +3V3 NET0150 4.7k
C51 VREF+_FCC 0 100n
R93 VREF+_FCC VDDA_FCC 47
C92 VDDA_FCC 0 100n
R79 0 Net-_LED6-K_ 330
R25 0 Net-_LED22-K_ 330
DLED14 Net-_LED14-K_ NET0058 LED_D_B
R39 0 Net-_LED14-K_ 100
C43 NET0092 0 100n
R55 0 Net-_LED18-K_ 330
DLED10 Net-_LED10-K_ NET0074 LED_D_B
DLED18 Net-_LED18-K_ NET0086 LED_D_Y
R85 0 Net-_LED10-K_ 100
DLED6 Net-_LED6-K_ NET0012 LED_D_R
DLED22 Net-_LED22-K_ NET0083 LED_D_R
C15 +3V3 0 100n
C48 +3V3 0 100n
C77 +3V3 0 100n
C53 +3V3 0 100n
C104 +3V3 0 100n
C8 +3V3 0 100n
C6 +3V3 0 100n
C23 Net-_FCC2-PH0_ 0 2.2u
C35 unconnected-_C35-Pad1_ 0 2.2u
R49 Net-_SW7-C_ NET0005 10k
R75 NET0085 Net-_C1-Pad1_ 620
C1 Net-_C1-Pad1_ 0 10p
C13 NET0031 0 10p
R84 +3V3 NET0166 4.7k
R81 +3V3 NET0065 4.7k
R17 +3V3 NET0125 4.7k
R36 +3V3 NET0075 4.7k
DLED8 Net-_LED8-K_ NET0040 LED_D_Y
DLED4 Net-_LED4-K_ NET0020 LED_D_B
R65 0 Net-_LED8-K_ 330
R86 0 Net-_LED4-K_ 100
DLED11 Net-_LED11-K_ NET0122 LED_D_R
R8 0 Net-_LED11-K_ 330
DLED5 Net-_LED5-K_ NET0037 LED_D_R
R41 0 Net-_LED5-K_ 330
C61 Net-_NAVC2-PH1_ 0 2.2u
C105 Net-_NAVC2-PH0_ 0 2.2u
C103 +3V3 0 100n
C19 +3V3 0 100n
C83 VDDA_NAVC 0 100n
C46 +3V3 0 100n
C112 +3V3 0 100n
C49 +3V3 0 100n
C109 +3V3 0 100n
C20 +3V3 0 100n
C73 +3V3 0 100n
C32 +3V3 0 100n
R24 Net-_SW1-C_ NET0043 10k
C84 NET0177 0 100n
R66 Net-_SW5-C_ NET0117 10k
R82 NET0101 NET0163 10
R70 NET0162 NET0165 10
R5 NET0064 NET0160 10
R94 NET0035 NET0121 10
R19 NET0003 NET0067 10
R91 NET0039 NET0081 10
R31 NET0105 NET0090 10
R60 NET0082 NET0175 10
R37 NET0063 Net-_USB4-D-_ 22
R50 NET0155 Net-_USB4-ID_ 560
R18 NET0146 Net-_USB4-D+_ 22
R74 NET0134 Net-_USB6-D+_ 22
R87 NET0004 Net-_USB6-D-_ 22
R9 NET0112 Net-_USB6-ID_ 560
C45 0 unconnected-_C45-Pad2_ 100n
C16 0 Net-_D2-A_ 100n
DLED3 Net-_LED3-K_ Net-_D2-A_ LED_D_G
R2 0 Net-_LED3-K_ 560
C78 0 unconnected-_C78-Pad2_ 100n
C106 0 Net-_D4-A_ 100n
DLED17 Net-_LED17-K_ Net-_D4-A_ LED_D_G
R16 0 Net-_LED17-K_ 560
R6 NET0106 NET0061 10
R47 NET0052 NET0076 10
R38 NET0109 NET0011 0
R42 NET0093 NET0172 0
C110 +3.3V 0 100n
R10 +3.3V Net-_U19-_WP__IO2__ 10k
R68 +3.3V Net-_U19-_HOLD__IO3__ 10k
C37 0 +3.3V 100n
C71 +3.3V 0 100n
C97 +3.3V 0 100n
C95 +3.3V 0 100n
C28 +3.3V 0 1u
C39 +3.3V 0 1u
C58 +3.3V 0 100n
C67 +3.3V 0 100n
C47 Net-_U15-C1_ 0 220n
R40 +3.3V NET0068 10k
C56 +3.3V 0 10u
R52 Net-_L3-Pad1_ Net-_U16-VCC_RF_ 10
C29 Net-_ANT2-Pad1_ Net-_U16-RF_IN_ 22p
C64 Net-_ANT2-Pad1_ 0 10n
L3 Net-_L3-Pad1_ Net-_ANT2-Pad1_ 27n
C55 +3.3V 0 100n
C98 +3.3V 0 100n
C80 Net-_U3-VO-_ Net-_U3-VO+_ 1n
C76 +3.3V 0 100n
R15 +3.3V NET0008 10k

V_3_3V +3.3V 0 DC 3.3
V_3V3 +3V3 0 DC 3.3
V_5V +5V 0 DC 5.0

.control
tran 100u 10m
set filetype=ascii
write Hades_raw.raw all
.endc

.end
