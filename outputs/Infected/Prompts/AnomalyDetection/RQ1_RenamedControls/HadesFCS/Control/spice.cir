.title KiCad schematic

.model LED_D_G D (Is=1p Rs=10 N=1.7)
.model LED_D_B D (Is=1p Rs=10 N=1.7)
.model LED_D_Y D (Is=1p Rs=10 N=1.7)
.model LED_D_R D (Is=1p Rs=10 N=1.7)

R16 NET0040 VIN+ 0.01
C31 +3.3V 0 100n
C103 +5V NET0099 4.7n
L3 NET0049 +5V 15u
R62 +5V NET0099 6.8k
C51 +5V 0 47u
C50 +5V 0 100u
C35 NET0049 Net-_C35-Pad2_ 100n
R72 0 NET0099 1.3k
R73 Net-_C35-Pad2_ NET0099 19.6k
C111 NET0049 NET0161 100n
DLED20 Net-_LED20-K_ +5V LED_D_G
R42 0 Net-_LED20-K_ 560
R43 NET0124 Net-_D4-A_ 10k
C40 Net-_D4-A_ 0 2.2u
C105 Net-_REG2-PVDD_ 0 2.2u
R12 NET0040 NET0014 10k
C26 NET0040 0 100u
C28 NET0040 0 47u
R3 0 Net-_LED21-K_ 240
DLED21 Net-_LED21-K_ +3.3V LED_D_G
C55 +5V 0 10u
C27 +3.3V 0 10u
C73 NET0030 0 10p
C52 Net-_C52-Pad1_ 0 10p
R11 NET0108 Net-_C52-Pad1_ 620
C44 +3V3 0 100n
C63 +3V3 0 100n
R48 +3V3 NET0130 4.7k
R39 +3V3 NET0085 4.7k
R38 +3V3 NET0038 4.7k
R23 +3V3 NET0105 4.7k
C104 +3V3 0 100n
C110 +3V3 0 100n
DLED22 Net-_LED22-K_ NET0139 LED_D_B
R91 0 Net-_LED22-K_ 100
R40 +3V3 NET0168 4.7k
R36 +3V3 NET0163 4.7k
C108 VREF+_FCC 0 100n
R44 VREF+_FCC VDDA_FCC 47
C42 VDDA_FCC 0 100n
R86 0 Net-_LED7-K_ 330
R30 0 Net-_LED8-K_ 330
DLED19 Net-_LED19-K_ NET0069 LED_D_B
R17 0 Net-_LED19-K_ 100
C10 NET0023 0 100n
R21 0 Net-_LED9-K_ 330
DLED18 Net-_LED18-K_ NET0090 LED_D_B
DLED9 Net-_LED9-K_ NET0009 LED_D_Y
R64 0 Net-_LED18-K_ 100
DLED7 Net-_LED7-K_ NET0131 LED_D_R
DLED8 Net-_LED8-K_ NET0066 LED_D_R
C106 +3V3 0 100n
C12 +3V3 0 100n
C76 +3V3 0 100n
C94 +3V3 0 100n
C45 +3V3 0 100n
C96 +3V3 0 100n
C68 +3V3 0 100n
C43 Net-_FCC2-PH0_ 0 2.2u
C91 unconnected-_C91-Pad1_ 0 2.2u
R52 Net-_SW8-C_ NET0081 10k
R15 NET0115 Net-_C77-Pad1_ 620
C77 Net-_C77-Pad1_ 0 10p
C49 NET0106 0 10p
R87 +3V3 NET0174 4.7k
R90 +3V3 NET0025 4.7k
R56 +3V3 NET0047 4.7k
R53 +3V3 NET0063 4.7k
DLED17 Net-_LED17-K_ NET0096 LED_D_Y
DLED15 Net-_LED15-K_ NET0142 LED_D_B
R70 0 Net-_LED17-K_ 330
R24 0 Net-_LED15-K_ 100
DLED2 Net-_LED2-K_ NET0119 LED_D_R
R94 0 Net-_LED2-K_ 330
DLED16 Net-_LED16-K_ NET0104 LED_D_R
R79 0 Net-_LED16-K_ 330
C18 Net-_NAVC2-PH1_ 0 2.2u
C34 Net-_NAVC2-PH0_ 0 2.2u
C72 +3V3 0 100n
C86 +3V3 0 100n
C71 VDDA_NAVC 0 100n
C53 +3V3 0 100n
C61 +3V3 0 100n
C30 +3V3 0 100n
C23 +3V3 0 100n
C65 +3V3 0 100n
C29 +3V3 0 100n
C22 +3V3 0 100n
R71 Net-_SW2-C_ NET0117 10k
C1 NET0120 0 100n
R69 Net-_SW7-C_ NET0138 10k
R63 NET0015 NET0166 10
R41 NET0080 NET0162 10
R74 NET0071 NET0043 10
R78 NET0004 NET0093 10
R67 NET0039 NET0137 10
R35 NET0068 NET0035 10
R81 NET0128 NET0034 10
R68 NET0062 NET0012 10
R92 NET0020 Net-_USB2-D-_ 22
R50 NET0011 Net-_USB2-ID_ 560
R22 NET0016 Net-_USB2-D+_ 22
R46 NET0164 Net-_USB6-D+_ 22
R82 NET0152 Net-_USB6-D-_ 22
R75 NET0031 Net-_USB6-ID_ 560
DLED14 Net-_LED14-K_ Net-_D2-A_ LED_D_G
R29 0 Net-_LED14-K_ 560
C88 0 Net-_D2-A_ 100n
R25 0 Net-_LED11-K_ 560
DLED11 Net-_LED11-K_ Net-_D8-A_ LED_D_G
C24 0 Net-_D8-A_ 100n
R83 NET0145 NET0085 0
R7 NET0037 NET0105 0
R66 NET0001 NET0088 10
R65 NET0100 NET0045 10
C38 0 unconnected-_C38-Pad2_ 100n
C2 0 unconnected-_C2-Pad2_ 100n
C84 +3.3V 0 100n
R32 +3.3V Net-_U2-_WP__IO2__ 10k
R80 +3.3V Net-_U2-_HOLD__IO3__ 10k
C16 0 +3.3V 100n
C100 +3.3V 0 100n
C9 +3.3V 0 100n
C5 +3.3V 0 100n
C25 +3.3V 0 1u
C4 +3.3V 0 1u
C74 +3.3V 0 100n
C92 +3.3V 0 100n
C32 Net-_U12-C1_ 0 220n
R93 +3.3V NET0153 10k
C113 +3.3V 0 10u
R57 Net-_L1-Pad1_ Net-_U9-VCC_RF_ 10
C47 Net-_ANT2-Pad1_ Net-_U9-RF_IN_ 22p
C13 Net-_ANT2-Pad1_ 0 10n
L1 Net-_L1-Pad1_ Net-_ANT2-Pad1_ 27n
C95 +3.3V 0 100n
C87 +3.3V 0 100n
C102 Net-_U18-VO-_ Net-_U18-VO+_ 1n
C90 +3.3V 0 100n
R19 +3.3V NET0003 10k

V_3_3V +3.3V 0 DC 3.3
V_3V3 +3V3 0 DC 3.3
V_5V +5V 0 DC 5.0

.control
tran 100u 10m
set filetype=ascii
write Hades_raw.raw all
.endc

.end
