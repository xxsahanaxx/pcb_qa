.title KiCad schematic

.model LED_D_G D (Is=1p Rs=10 N=1.7)
.model LED_D_B D (Is=1p Rs=10 N=1.7)
.model LED_D_Y D (Is=1p Rs=10 N=1.7)
.model LED_D_R D (Is=1p Rs=10 N=1.7)

R78 NET0118 VIN+ 0.01
C71 +3.3V 0 100n
C110 +5V NET0073 4.7n
L2 NET0034 +5V 15u
R34 +5V NET0073 6.8k
C46 +5V 0 47u
C60 +5V 0 100u
C40 NET0034 Net-_C40-Pad2_ 100n
R71 0 NET0073 1.3k
R62 Net-_C40-Pad2_ NET0073 19.6k
C81 NET0034 NET0172 100n
DLED10 Net-_LED10-K_ +5V LED_D_G
R28 0 Net-_LED10-K_ 560
R66 NET0001 Net-_D2-A_ 10k
C23 Net-_D2-A_ 0 2.2u
C41 Net-_REG2-PVDD_ 0 2.2u
R56 NET0118 NET0177 10k
C61 NET0118 0 100u
C47 NET0118 0 47u
R81 0 Net-_LED22-K_ 240
DLED22 Net-_LED22-K_ +3.3V LED_D_G
C105 +5V 0 10u
C6 +3.3V 0 10u
C30 NET0115 0 10p
C55 Net-_C55-Pad1_ 0 10p
R39 NET0048 Net-_C55-Pad1_ 620
C37 +3V3 0 100n
C5 +3V3 0 100n
R88 +3V3 NET0044 4.7k
R15 +3V3 NET0026 4.7k
R37 +3V3 NET0095 4.7k
C21 +3V3 0 100n
R5 +3V3 NET0163 4.7k
C79 +3V3 0 100n
DLED16 Net-_LED16-K_ NET0011 LED_D_B
R79 0 Net-_LED16-K_ 100
R29 +3V3 NET0111 4.7k
R75 +3V3 NET0165 4.7k
C35 VREF+_FCC 0 100n
R55 VREF+_FCC VDDA_FCC 47
C49 VDDA_FCC 0 100n
R70 0 Net-_LED21-K_ 330
R74 0 Net-_LED7-K_ 330
DLED15 Net-_LED15-K_ NET0105 LED_D_B
R11 0 Net-_LED15-K_ 100
C27 NET0151 0 100n
R60 0 Net-_LED13-K_ 330
DLED18 Net-_LED18-K_ NET0002 LED_D_B
DLED13 Net-_LED13-K_ NET0175 LED_D_Y
R86 0 Net-_LED18-K_ 100
DLED21 Net-_LED21-K_ NET0054 LED_D_R
DLED7 Net-_LED7-K_ NET0126 LED_D_R
C58 +3V3 0 100n
C48 +3V3 0 100n
C82 +3V3 0 100n
C32 +3V3 0 100n
C57 +3V3 0 100n
C36 +3V3 0 100n
C64 +3V3 0 100n
C4 Net-_FCC2-PH0_ 0 2.2u
C100 unconnected-_C100-Pad1_ 0 2.2u
R90 Net-_SW1-C_ NET0050 10k
R61 NET0100 Net-_C83-Pad1_ 620
C83 Net-_C83-Pad1_ 0 10p
C34 NET0156 0 10p
R10 +3V3 NET0171 4.7k
R42 +3V3 NET0149 4.7k
R45 +3V3 NET0067 4.7k
R19 +3V3 NET0056 4.7k
DLED20 Net-_LED20-K_ NET0077 LED_D_Y
DLED3 Net-_LED3-K_ NET0096 LED_D_B
R40 0 Net-_LED20-K_ 330
R44 0 Net-_LED3-K_ 100
DLED14 Net-_LED14-K_ NET0137 LED_D_R
R48 0 Net-_LED14-K_ 330
DLED12 Net-_LED12-K_ NET0058 LED_D_R
R58 0 Net-_LED12-K_ 330
C107 Net-_NAVC2-PH1_ 0 2.2u
C54 Net-_NAVC2-PH0_ 0 2.2u
C50 +3V3 0 100n
C38 +3V3 0 100n
C78 VDDA_NAVC 0 100n
C89 +3V3 0 100n
C97 +3V3 0 100n
C62 +3V3 0 100n
C8 +3V3 0 100n
C101 +3V3 0 100n
C16 +3V3 0 100n
C53 +3V3 0 100n
R63 Net-_SW4-C_ NET0009 10k
C15 NET0061 0 100n
R59 Net-_SW3-C_ NET0017 10k
R94 NET0147 NET0157 10
R2 NET0023 NET0060 10
R65 NET0088 NET0072 10
R35 NET0139 NET0042 10
R67 NET0101 NET0027 10
R21 NET0131 NET0121 10
R12 NET0146 NET0145 10
R38 NET0102 NET0082 10
R46 NET0066 Net-_USB4-D-_ 22
R20 NET0014 Net-_USB4-ID_ 560
R50 NET0127 Net-_USB4-D+_ 22
R51 NET0028 Net-_USB6-D+_ 22
R69 NET0037 Net-_USB6-D-_ 22
R17 NET0117 Net-_USB6-ID_ 560
C12 0 unconnected-_C12-Pad2_ 100n
C98 0 Net-_D3-A_ 100n
DLED8 Net-_LED8-K_ Net-_D3-A_ LED_D_G
R49 0 Net-_LED8-K_ 560
C59 0 unconnected-_C59-Pad2_ 100n
C112 0 Net-_D8-A_ 100n
DLED5 Net-_LED5-K_ Net-_D8-A_ LED_D_G
R89 0 Net-_LED5-K_ 560
R18 NET0045 NET0167 10
R57 NET0123 NET0085 10
R36 NET0091 NET0163 0
R25 NET0161 NET0095 0
C88 +3.3V 0 100n
R24 +3.3V Net-_U8-_WP__IO2__ 10k
R93 +3.3V Net-_U8-_HOLD__IO3__ 10k
C103 0 +3.3V 100n
C31 +3.3V 0 100n
C33 +3.3V 0 100n
C86 +3.3V 0 100n
C56 +3.3V 0 1u
C113 +3.3V 0 1u
C102 +3.3V 0 100n
C11 +3.3V 0 100n
C85 Net-_U9-C1_ 0 220n
R8 +3.3V NET0063 10k
C74 +3.3V 0 10u
R76 Net-_L3-Pad1_ Net-_U11-VCC_RF_ 10
C70 Net-_ANT2-Pad1_ Net-_U11-RF_IN_ 22p
C84 Net-_ANT2-Pad1_ 0 10n
L3 Net-_L3-Pad1_ Net-_ANT2-Pad1_ 27n
C22 +3.3V 0 100n
C17 +3.3V 0 100n
C90 Net-_U16-VO-_ Net-_U16-VO+_ 1n
C87 +3.3V 0 100n
R82 +3.3V NET0087 10k

V_3_3V +3.3V 0 DC 3.3
V_3V3 +3V3 0 DC 3.3
V_5V +5V 0 DC 5.0

.control
tran 100u 10m
set filetype=ascii
write Hades_raw.raw all
.endc

.end
