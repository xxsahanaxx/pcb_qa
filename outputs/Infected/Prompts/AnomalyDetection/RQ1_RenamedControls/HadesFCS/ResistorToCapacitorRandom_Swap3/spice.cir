.title KiCad schematic

.model LED_D_G D (Is=1p Rs=10 N=1.7)
.model LED_D_B D (Is=1p Rs=10 N=1.7)
.model LED_D_Y D (Is=1p Rs=10 N=1.7)
.model LED_D_R D (Is=1p Rs=10 N=1.7)

R51 NET0129 VIN+ 0.01
C37 +3.3V 0 100n
C9 +5V NET0028 4.7n
L2 NET0015 +5V 15u
R52 +5V NET0028 6.8k
C87 +5V 0 47u
C24 +5V 0 100u
C80 NET0015 Net-_C80-Pad2_ 100n
R74 0 NET0028 1.3k
R8 Net-_C80-Pad2_ NET0028 19.6k
C108 NET0015 NET0044 100n
DLED17 Net-_LED17-K_ +5V LED_D_G
R63 0 Net-_LED17-K_ 560
R29 NET0138 Net-_D5-A_ 10k
C83 Net-_D5-A_ 0 2.2u
C50 Net-_REG3-PVDD_ 0 2.2u
R31 NET0129 NET0121 10k
C11 NET0129 0 100u
C70 NET0129 0 47u
R2 0 Net-_LED3-K_ 240
DLED3 Net-_LED3-K_ +3.3V LED_D_G
C99 +5V 0 10u
C23 +3.3V 0 10u
C66 NET0077 0 10p
C14 Net-_C14-Pad1_ 0 10p
R64 NET0057 Net-_C14-Pad1_ 620
C90 +3V3 0 100n
C91 +3V3 0 100n
R15 +3V3 NET0103 4.7k
R82 +3V3 NET0175 4.7k
R58 +3V3 NET0035 4.7k
R67 +3V3 NET0086 4.7k
C89 +3V3 0 100n
C39 +3V3 0 100n
DLED7 Net-_LED7-K_ NET0069 LED_D_B
R78 0 Net-_LED7-K_ 100
R86 +3V3 NET0097 4.7k
R17 +3V3 NET0053 4.7k
C41 VREF+_FCC 0 100n
R43 VREF+_FCC VDDA_FCC 47
C25 VDDA_FCC 0 100n
R45 0 Net-_LED20-K_ 330
R40 0 Net-_LED22-K_ 330
DLED9 Net-_LED9-K_ NET0123 LED_D_B
R93 0 Net-_LED9-K_ 100
C17 NET0172 0 100n
R36 0 Net-_LED6-K_ 330
DLED13 Net-_LED13-K_ NET0165 LED_D_B
DLED6 Net-_LED6-K_ NET0001 LED_D_Y
R83 0 Net-_LED13-K_ 100
DLED20 Net-_LED20-K_ NET0170 LED_D_R
DLED22 Net-_LED22-K_ NET0046 LED_D_R
C29 +3V3 0 100n
C31 +3V3 0 100n
C107 +3V3 0 100n
C113 +3V3 0 100n
C34 +3V3 0 100n
C16 +3V3 0 100n
C18 +3V3 0 100n
C65 Net-_FCC2-PH0_ 0 2.2u
C92 unconnected-_C92-Pad1_ 0 2.2u
R42 Net-_SW6-C_ NET0109 10k
R89 NET0009 Net-_C42-Pad1_ 620
C42 Net-_C42-Pad1_ 0 10p
C97 NET0167 0 10p
R55 +3V3 NET0116 4.7k
R73 +3V3 NET0024 4.7k
R25 +3V3 NET0155 4.7k
R21 +3V3 NET0070 4.7k
DLED2 Net-_LED2-K_ NET0106 LED_D_Y
DLED8 Net-_LED8-K_ NET0135 LED_D_B
R46 0 Net-_LED2-K_ 330
R12 0 Net-_LED8-K_ 100
DLED4 Net-_LED4-K_ NET0004 LED_D_R
R66 0 Net-_LED4-K_ 330
DLED5 Net-_LED5-K_ NET0021 LED_D_R
R75 0 Net-_LED5-K_ 330
C68 Net-_NAVC2-PH1_ 0 2.2u
C111 Net-_NAVC2-PH0_ 0 2.2u
C48 +3V3 0 100n
C20 +3V3 0 100n
C44 VDDA_NAVC 0 100n
C10 +3V3 0 100n
C96 +3V3 0 100n
C8 +3V3 0 100n
C13 +3V3 0 100n
C30 +3V3 0 100n
C40 +3V3 0 100n
C100 +3V3 0 100n
R71 Net-_SW5-C_ NET0117 10k
C79 NET0128 0 100n
R94 Net-_SW1-C_ NET0059 10k
R62 NET0008 NET0019 10
R80 NET0012 NET0026 10
R65 NET0013 NET0006 10
R54 NET0085 NET0036 10
R14 NET0005 NET0016 10
R6 NET0134 NET0120 10
R27 NET0020 NET0092 10
R76 NET0032 NET0045 10
R91 NET0096 Net-_USB3-D-_ 22
R10 NET0068 Net-_USB3-ID_ 560
R56 NET0150 Net-_USB3-D+_ 22
R26 NET0176 Net-_USB1-D+_ 22
R60 NET0094 Net-_USB1-D-_ 22
R3 NET0115 Net-_USB1-ID_ 560
DLED10 Net-_LED10-K_ Net-_D7-A_ LED_D_G
R22 0 Net-_LED10-K_ 560
C75 0 Net-_D7-A_ 100n
R69 0 Net-_LED21-K_ 560
DLED21 Net-_LED21-K_ Net-_D2-A_ LED_D_G
C54 0 Net-_D2-A_ 100n
R5 NET0163 NET0175 0
R85 NET0168 NET0086 0
R92 NET0029 NET0071 10
R23 NET0132 NET0055 10
C55 0 unconnected-_C55-Pad2_ 100n
C15 0 unconnected-_C15-Pad2_ 100n
C103 +3.3V 0 100n
R79 +3.3V Net-_U16-_WP__IO2__ 10k
R16 +3.3V Net-_U16-_HOLD__IO3__ 10k
C85 0 +3.3V 100n
C57 +3.3V 0 100n
C56 +3.3V 0 100n
C94 +3.3V 0 100n
C33 +3.3V 0 1u
C27 +3.3V 0 1u
C112 +3.3V 0 100n
C84 +3.3V 0 100n
C52 Net-_U11-C1_ 0 220n
R84 +3.3V NET0151 10k
C102 +3.3V 0 10u
R68 Net-_L3-Pad1_ Net-_U14-VCC_RF_ 10
C60 Net-_ANT2-Pad1_ Net-_U14-RF_IN_ 22p
C4 Net-_ANT2-Pad1_ 0 10n
L3 Net-_L3-Pad1_ Net-_ANT2-Pad1_ 27n
C88 +3.3V 0 100n
C61 +3.3V 0 100n
C62 Net-_U9-VO-_ Net-_U9-VO+_ 1n
C12 +3.3V 0 100n
R7 +3.3V NET0126 10k

V_3_3V +3.3V 0 DC 3.3
V_3V3 +3V3 0 DC 3.3
V_5V +5V 0 DC 5.0

.control
tran 100u 10m
set filetype=ascii
write Hades_raw.raw all
.endc

.end
