.title KiCad schematic

.model LED_D_G D (Is=1p Rs=10 N=1.7)
.model LED_D_B D (Is=1p Rs=10 N=1.7)
.model LED_D_Y D (Is=1p Rs=10 N=1.7)
.model LED_D_R D (Is=1p Rs=10 N=1.7)

R12 NET0013 VIN+ 0.01
C12 +3.3V 0 100n
C17 +5V NET0142 4.7n
L2 NET0007 +5V 15u
R57 +5V NET0142 6.8k
C82 +5V 0 47u
C33 +5V 0 100u
C49 NET0007 Net-_C49-Pad2_ 100n
R35 0 NET0142 1.3k
R72 Net-_C49-Pad2_ NET0142 19.6k
C31 NET0007 NET0169 100n
DLED5 Net-_LED5-K_ +5V LED_D_G
R63 0 Net-_LED5-K_ 560
R85 NET0041 Net-_D4-A_ 10k
C19 Net-_D4-A_ 0 2.2u
C23 NET0013 0 100u
C101 NET0013 0 47u
R67 NET0013 NET0163 10k
C64 Net-_REG2-PVDD_ 0 2.2u
R44 0 Net-_LED15-K_ 240
DLED15 Net-_LED15-K_ +3.3V LED_D_G
C46 +5V 0 10u
C43 +3.3V 0 10u
C40 NET0137 0 10p
C106 Net-_C106-Pad1_ 0 10p
R34 NET0106 Net-_C106-Pad1_ 620
C14 +3V3 0 100n
C55 +3V3 0 100n
R2 +3V3 NET0053 4.7k
R78 +3V3 NET0098 4.7k
R10 +3V3 NET0165 4.7k
R6 +3V3 NET0016 4.7k
C63 +3V3 0 100n
C70 +3V3 0 100n
DLED19 Net-_LED19-K_ NET0097 LED_D_B
R30 0 Net-_LED19-K_ 100
R39 +3V3 NET0036 4.7k
R42 +3V3 NET0099 4.7k
C52 VREF+_FCC 0 100n
R1 VREF+_FCC VDDA_FCC 47
C60 VDDA_FCC 0 100n
R71 0 Net-_LED8-K_ 330
R29 0 Net-_LED21-K_ 330
DLED3 Net-_LED3-K_ NET0148 LED_D_B
R32 0 Net-_LED3-K_ 100
C37 NET0025 0 100n
R56 0 Net-_LED22-K_ 330
DLED18 Net-_LED18-K_ NET0120 LED_D_B
DLED22 Net-_LED22-K_ NET0128 LED_D_Y
R58 0 Net-_LED18-K_ 100
DLED8 Net-_LED8-K_ NET0118 LED_D_R
DLED21 Net-_LED21-K_ NET0012 LED_D_R
C78 +3V3 0 100n
C96 +3V3 0 100n
C30 +3V3 0 100n
C36 +3V3 0 100n
C59 +3V3 0 100n
C42 +3V3 0 100n
C105 +3V3 0 100n
C34 Net-_FCC2-PH0_ 0 2.2u
C110 unconnected-_C110-Pad1_ 0 2.2u
R61 Net-_SW1-C_ NET0151 10k
R90 NET0117 Net-_C72-Pad1_ 620
C72 Net-_C72-Pad1_ 0 10p
C13 NET0060 0 10p
R54 +3V3 NET0057 4.7k
R36 +3V3 NET0063 4.7k
R17 +3V3 NET0074 4.7k
R82 +3V3 NET0064 4.7k
DLED1 Net-_LED1-K_ NET0114 LED_D_Y
DLED9 Net-_LED9-K_ NET0110 LED_D_B
R33 0 Net-_LED1-K_ 330
R21 0 Net-_LED9-K_ 100
DLED13 Net-_LED13-K_ NET0159 LED_D_R
R65 0 Net-_LED13-K_ 330
DLED11 Net-_LED11-K_ NET0103 LED_D_R
R5 0 Net-_LED11-K_ 330
C1 Net-_NAVC2-PH1_ 0 2.2u
C54 Net-_NAVC2-PH0_ 0 2.2u
C24 +3V3 0 100n
C38 +3V3 0 100n
C99 VDDA_NAVC 0 100n
C68 +3V3 0 100n
C4 +3V3 0 100n
C102 +3V3 0 100n
C73 +3V3 0 100n
C48 +3V3 0 100n
C47 +3V3 0 100n
C56 +3V3 0 100n
R48 Net-_SW2-C_ NET0026 10k
C83 NET0177 0 100n
R22 Net-_SW8-C_ NET0038 10k
R91 NET0046 NET0093 10
R81 NET0073 NET0145 10
R24 NET0049 NET0111 10
R76 NET0115 NET0014 10
R14 NET0067 NET0043 10
R47 NET0082 NET0022 10
R46 NET0153 NET0035 10
R94 NET0158 NET0083 10
R83 NET0048 Net-_USB2-D-_ 22
R13 NET0175 Net-_USB2-ID_ 560
R86 NET0101 Net-_USB2-D+_ 22
R73 NET0155 Net-_USB3-D+_ 22
R69 NET0123 Net-_USB3-D-_ 22
R64 NET0154 Net-_USB3-ID_ 560
C8 0 unconnected-_C8-Pad2_ 100n
C62 0 Net-_D3-A_ 100n
DLED7 Net-_LED7-K_ Net-_D3-A_ LED_D_G
R3 0 Net-_LED7-K_ 560
C6 0 unconnected-_C6-Pad2_ 100n
C85 0 Net-_D1-A_ 100n
DLED20 Net-_LED20-K_ Net-_D1-A_ LED_D_G
R4 0 Net-_LED20-K_ 560
R50 NET0020 NET0133 10
R77 NET0157 NET0056 10
R52 NET0147 NET0098 0
R26 NET0024 NET0016 0
C5 +3.3V 0 100n
R38 +3.3V Net-_U10-_WP__IO2__ 10k
R84 +3.3V Net-_U10-_HOLD__IO3__ 10k
C80 0 +3.3V 100n
C86 +3.3V 0 100n
C69 +3.3V 0 100n
C50 +3.3V 0 100n
C98 +3.3V 0 1u
C15 +3.3V 0 1u
C32 +3.3V 0 100n
C93 +3.3V 0 100n
C113 Net-_U11-C1_ 0 220n
R8 +3.3V NET0047 10k
C58 +3.3V 0 10u
R70 Net-_L3-Pad1_ Net-_U13-VCC_RF_ 10
C29 Net-_ANT2-Pad1_ Net-_U13-RF_IN_ 22p
C107 Net-_ANT2-Pad1_ 0 10n
L3 Net-_L3-Pad1_ Net-_ANT2-Pad1_ 27n
C92 +3.3V 0 100n
C100 +3.3V 0 100n
C112 Net-_U17-VO-_ Net-_U17-VO+_ 1n
C53 +3.3V 0 100n
R27 +3.3V NET0122 10k

V_3_3V +3.3V 0 DC 3.3
V_3V3 +3V3 0 DC 3.3
V_5V +5V 0 DC 5.0

.control
tran 100u 10m
set filetype=ascii
write Hades_raw.raw all
.endc

.end
