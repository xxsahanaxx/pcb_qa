.title KiCad schematic

.model LED_D_G D (Is=1p Rs=10 N=1.7)
.model LED_D_B D (Is=1p Rs=10 N=1.7)
.model LED_D_Y D (Is=1p Rs=10 N=1.7)
.model LED_D_R D (Is=1p Rs=10 N=1.7)

R35 NET0078 VIN+ 0.01
C88 +3.3V 0 100n
C86 +5V NET0164 4.7n
L2 NET0075 +5V 15u
R24 +5V NET0164 6.8k
C85 +5V 0 47u
C75 +5V 0 100u
C32 NET0075 Net-_C32-Pad2_ 100n
R5 0 NET0164 1.3k
R40 Net-_C32-Pad2_ NET0164 19.6k
C21 NET0075 NET0064 100n
DLED20 Net-_LED20-K_ +5V LED_D_G
R70 0 Net-_LED20-K_ 560
R21 NET0118 Net-_D3-A_ 10k
C15 Net-_D3-A_ 0 2.2u
C64 NET0078 0 100u
C101 NET0078 0 47u
R67 NET0078 NET0176 10k
C62 Net-_REG2-PVDD_ 0 2.2u
R26 0 Net-_LED14-K_ 240
DLED14 Net-_LED14-K_ +3.3V LED_D_G
C33 +5V 0 10u
C57 +3.3V 0 10u
C110 NET0156 0 10p
C39 Net-_C39-Pad1_ 0 10p
R20 NET0094 Net-_C39-Pad1_ 620
C74 +3V3 0 100n
C47 +3V3 0 100n
R43 +3V3 NET0123 4.7k
R71 +3V3 NET0096 4.7k
R25 +3V3 NET0054 4.7k
R39 +3V3 NET0044 4.7k
C30 +3V3 0 100n
C81 +3V3 0 100n
DLED4 Net-_LED4-K_ NET0067 LED_D_B
R32 0 Net-_LED4-K_ 100
R38 +3V3 NET0146 4.7k
R77 +3V3 NET0116 4.7k
C59 VREF+_FCC 0 100n
R89 VREF+_FCC VDDA_FCC 47
C7 VDDA_FCC 0 100n
R78 0 Net-_LED12-K_ 330
R36 0 Net-_LED22-K_ 330
DLED11 Net-_LED11-K_ NET0077 LED_D_B
R41 0 Net-_LED11-K_ 100
C90 NET0029 0 100n
R87 0 Net-_LED6-K_ 330
DLED3 Net-_LED3-K_ NET0148 LED_D_B
DLED6 Net-_LED6-K_ NET0086 LED_D_Y
R6 0 Net-_LED3-K_ 100
DLED12 Net-_LED12-K_ NET0138 LED_D_R
DLED22 Net-_LED22-K_ NET0045 LED_D_R
C10 +3V3 0 100n
C41 +3V3 0 100n
C63 +3V3 0 100n
C44 +3V3 0 100n
C79 +3V3 0 100n
C97 +3V3 0 100n
C102 +3V3 0 100n
C82 Net-_FCC2-PH0_ 0 2.2u
C35 unconnected-_C35-Pad1_ 0 2.2u
R15 Net-_SW4-C_ NET0055 10k
R30 NET0006 Net-_C27-Pad1_ 620
C27 Net-_C27-Pad1_ 0 10p
C17 NET0011 0 10p
R23 +3V3 NET0018 4.7k
R91 +3V3 NET0063 4.7k
R37 +3V3 NET0144 4.7k
R8 +3V3 NET0057 4.7k
DLED21 Net-_LED21-K_ NET0112 LED_D_Y
DLED17 Net-_LED17-K_ NET0113 LED_D_B
R88 0 Net-_LED21-K_ 330
R45 0 Net-_LED17-K_ 100
DLED8 Net-_LED8-K_ NET0149 LED_D_R
R22 0 Net-_LED8-K_ 330
DLED5 Net-_LED5-K_ NET0036 LED_D_R
R64 0 Net-_LED5-K_ 330
C98 Net-_NAVC2-PH1_ 0 2.2u
C49 Net-_NAVC2-PH0_ 0 2.2u
C103 +3V3 0 100n
C14 +3V3 0 100n
C28 VDDA_NAVC 0 100n
C13 +3V3 0 100n
C25 +3V3 0 100n
C92 +3V3 0 100n
C66 +3V3 0 100n
C99 +3V3 0 100n
C84 +3V3 0 100n
C34 +3V3 0 100n
R57 Net-_SW1-C_ NET0071 10k
C107 NET0129 0 100n
R53 Net-_SW8-C_ NET0122 10k
R48 NET0100 NET0034 10
R81 NET0047 NET0051 10
R84 NET0033 NET0119 10
R65 NET0023 NET0126 10
R13 NET0108 NET0008 10
R82 NET0127 NET0171 10
R62 NET0074 NET0166 10
R11 NET0042 NET0035 10
R94 NET0084 Net-_USB4-D-_ 22
R63 NET0157 Net-_USB4-ID_ 560
R46 NET0022 Net-_USB4-D+_ 22
R42 NET0048 Net-_USB5-D+_ 22
R47 NET0003 Net-_USB5-D-_ 22
R60 NET0107 Net-_USB5-ID_ 560
C19 0 unconnected-_C19-Pad2_ 100n
C106 0 Net-_D8-A_ 100n
DLED9 Net-_LED9-K_ Net-_D8-A_ LED_D_G
R29 0 Net-_LED9-K_ 560
C42 0 unconnected-_C42-Pad2_ 100n
C89 0 Net-_D7-A_ 100n
DLED10 Net-_LED10-K_ Net-_D7-A_ LED_D_G
R9 0 Net-_LED10-K_ 560
R16 NET0143 NET0159 10
R69 NET0150 NET0162 10
R12 NET0056 NET0096 0
R80 NET0154 NET0044 0
C51 +3.3V 0 100n
R61 +3.3V Net-_U13-_WP__IO2__ 10k
R66 +3.3V Net-_U13-_HOLD__IO3__ 10k
C50 0 +3.3V 100n
C68 +3.3V 0 100n
C105 +3.3V 0 100n
C67 +3.3V 0 100n
C96 +3.3V 0 1u
C24 +3.3V 0 1u
C40 +3.3V 0 100n
C104 +3.3V 0 100n
C52 Net-_U10-C1_ 0 220n
R1 +3.3V NET0110 10k
C83 +3.3V 0 10u
R17 Net-_L1-Pad1_ Net-_U15-VCC_RF_ 10
C53 Net-_ANT2-Pad1_ Net-_U15-RF_IN_ 22p
C46 Net-_ANT2-Pad1_ 0 10n
L1 Net-_L1-Pad1_ Net-_ANT2-Pad1_ 27n
C9 +3.3V 0 100n
C69 +3.3V 0 100n
C18 Net-_U18-VO-_ Net-_U18-VO+_ 1n
C108 +3.3V 0 100n
R59 +3.3V NET0026 10k

V_3_3V +3.3V 0 DC 3.3
V_3V3 +3V3 0 DC 3.3
V_5V +5V 0 DC 5.0

.control
tran 100u 10m
set filetype=ascii
write Hades_raw.raw all
.endc

.end
