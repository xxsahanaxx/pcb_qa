.title KiCad schematic

.model LED_D_G D (Is=1p Rs=10 N=1.7)
.model LED_D_B D (Is=1p Rs=10 N=1.7)
.model LED_D_Y D (Is=1p Rs=10 N=1.7)
.model LED_D_R D (Is=1p Rs=10 N=1.7)

R26 NET0160 VIN+ 0.01
C40 +3.3V 0 100n
C105 +5V NET0011 4.7n
L3 NET0049 +5V 15u
R42 +5V NET0011 6.8k
C34 +5V 0 47u
C7 +5V 0 100u
C86 NET0049 Net-_C86-Pad2_ 100n
R24 0 NET0011 1.3k
R52 Net-_C86-Pad2_ NET0011 19.6k
C53 NET0049 NET0129 100n
DLED14 Net-_LED14-K_ +5V LED_D_G
R23 0 Net-_LED14-K_ 560
R48 NET0143 Net-_D4-A_ 10k
C109 Net-_D4-A_ 0 2.2u
C112 Net-_REG3-PVDD_ 0 2.2u
R87 NET0160 NET0012 10k
C99 NET0160 0 100u
C39 NET0160 0 47u
R46 0 Net-_LED9-K_ 240
DLED9 Net-_LED9-K_ +3.3V LED_D_G
C10 +5V 0 10u
C84 +3.3V 0 10u
C69 NET0087 0 10p
C46 Net-_C46-Pad1_ 0 10p
R51 NET0099 Net-_C46-Pad1_ 620
C44 +3V3 0 100n
C16 +3V3 0 100n
R72 +3V3 NET0064 4.7k
R12 +3V3 NET0075 4.7k
R31 +3V3 NET0132 4.7k
R25 +3V3 NET0156 4.7k
C49 +3V3 0 100n
C88 +3V3 0 100n
DLED10 Net-_LED10-K_ NET0117 LED_D_B
R57 0 Net-_LED10-K_ 100
R80 +3V3 NET0065 4.7k
R43 +3V3 NET0074 4.7k
C21 VREF+_FCC 0 100n
R82 VREF+_FCC VDDA_FCC 47
C45 VDDA_FCC 0 100n
R20 0 Net-_LED17-K_ 330
R84 0 Net-_LED20-K_ 330
DLED4 Net-_LED4-K_ NET0175 LED_D_B
R83 0 Net-_LED4-K_ 100
C106 NET0056 0 100n
R39 0 Net-_LED6-K_ 330
DLED22 Net-_LED22-K_ NET0114 LED_D_B
DLED6 Net-_LED6-K_ NET0164 LED_D_Y
R70 0 Net-_LED22-K_ 100
DLED17 Net-_LED17-K_ NET0019 LED_D_R
DLED20 Net-_LED20-K_ NET0013 LED_D_R
C71 +3V3 0 100n
C66 +3V3 0 100n
C104 +3V3 0 100n
C80 +3V3 0 100n
C68 +3V3 0 100n
C29 +3V3 0 100n
C91 +3V3 0 100n
C72 Net-_FCC2-PH0_ 0 2.2u
C9 unconnected-_C9-Pad1_ 0 2.2u
R35 Net-_SW1-C_ NET0044 10k
R93 NET0133 Net-_C81-Pad1_ 620
C81 Net-_C81-Pad1_ 0 10p
C15 NET0105 0 10p
R61 +3V3 NET0002 4.7k
R81 +3V3 NET0047 4.7k
R32 +3V3 NET0080 4.7k
R38 +3V3 NET0026 4.7k
DLED8 Net-_LED8-K_ NET0096 LED_D_Y
DLED16 Net-_LED16-K_ NET0092 LED_D_B
R45 0 Net-_LED8-K_ 330
R66 0 Net-_LED16-K_ 100
DLED11 Net-_LED11-K_ NET0169 LED_D_R
R22 0 Net-_LED11-K_ 330
DLED1 Net-_LED1-K_ NET0083 LED_D_R
R86 0 Net-_LED1-K_ 330
C18 Net-_NAVC2-PH1_ 0 2.2u
C96 Net-_NAVC2-PH0_ 0 2.2u
C100 +3V3 0 100n
C41 +3V3 0 100n
C5 VDDA_NAVC 0 100n
C37 +3V3 0 100n
C32 +3V3 0 100n
C67 +3V3 0 100n
C25 +3V3 0 100n
C30 +3V3 0 100n
C43 +3V3 0 100n
C4 +3V3 0 100n
R6 Net-_SW8-C_ NET0172 10k
C52 NET0089 0 100n
R16 Net-_SW2-C_ NET0177 10k
R34 NET0015 NET0055 10
R89 NET0062 NET0101 10
R71 NET0022 NET0007 10
R60 NET0070 NET0006 10
R3 NET0040 NET0046 10
R8 NET0010 NET0166 10
R74 NET0051 NET0104 10
R36 NET0072 NET0025 10
R55 NET0102 Net-_USB3-D-_ 22
R40 NET0054 Net-_USB3-ID_ 560
R33 NET0112 Net-_USB3-D+_ 22
R91 NET0106 Net-_USB4-D+_ 22
R4 NET0173 Net-_USB4-D-_ 22
R79 NET0063 Net-_USB4-ID_ 560
DLED19 Net-_LED19-K_ Net-_D2-A_ LED_D_G
R30 0 Net-_LED19-K_ 560
C12 0 Net-_D2-A_ 100n
R10 0 Net-_LED2-K_ 560
DLED2 Net-_LED2-K_ Net-_D8-A_ LED_D_G
C23 0 Net-_D8-A_ 100n
R63 NET0144 NET0075 0
R44 NET0157 NET0156 0
R41 NET0107 NET0088 10
R19 NET0116 NET0020 10
C14 0 unconnected-_C14-Pad2_ 100n
C17 0 unconnected-_C17-Pad2_ 100n
C92 +3.3V 0 100n
R18 +3.3V Net-_U19-_WP__IO2__ 10k
R56 +3.3V Net-_U19-_HOLD__IO3__ 10k
C55 0 +3.3V 100n
C75 +3.3V 0 100n
C85 +3.3V 0 100n
C74 +3.3V 0 100n
C87 +3.3V 0 1u
C51 +3.3V 0 1u
C8 +3.3V 0 100n
C60 +3.3V 0 100n
C107 Net-_U6-C1_ 0 220n
R17 +3.3V NET0016 10k
C38 +3.3V 0 10u
R73 Net-_L1-Pad1_ Net-_U9-VCC_RF_ 10
C42 Net-_ANT2-Pad1_ Net-_U9-RF_IN_ 22p
C93 Net-_ANT2-Pad1_ 0 10n
L1 Net-_L1-Pad1_ Net-_ANT2-Pad1_ 27n
C95 +3.3V 0 100n
C102 +3.3V 0 100n
C20 Net-_U13-VO-_ Net-_U13-VO+_ 1n
C79 +3.3V 0 100n
R94 +3.3V NET0005 10k

V_3_3V +3.3V 0 DC 3.3
V_3V3 +3V3 0 DC 3.3
V_5V +5V 0 DC 5.0

.control
tran 100u 10m
set filetype=ascii
write Hades_raw.raw all
.endc

.end
