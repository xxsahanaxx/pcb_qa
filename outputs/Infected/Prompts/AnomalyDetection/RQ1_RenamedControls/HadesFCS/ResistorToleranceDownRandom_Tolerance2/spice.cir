.title KiCad schematic

.model LED_D_G D (Is=1p Rs=10 N=1.7)
.model LED_D_B D (Is=1p Rs=10 N=1.7)
.model LED_D_Y D (Is=1p Rs=10 N=1.7)
.model LED_D_R D (Is=1p Rs=10 N=1.7)

R30 NET0130 VIN+ 0.01
C7 +3.3V 0 100n
C59 +5V NET0069 4.7n
L2 NET0047 +5V 15u
R67 +5V NET0069 6.8k
C4 +5V 0 47u
C98 +5V 0 100u
C5 NET0047 Net-_C5-Pad2_ 100n
R49 0 NET0069 1.3k
R70 Net-_C5-Pad2_ NET0069 19.6k
C88 NET0047 NET0131 100n
DLED19 Net-_LED19-K_ +5V LED_D_G
R66 0 Net-_LED19-K_ 560
R10 NET0072 Net-_D2-A_ 10k
C97 Net-_D2-A_ 0 2.2u
C45 NET0130 0 100u
C112 NET0130 0 47u
R80 NET0130 NET0087 10k
C110 Net-_REG3-PVDD_ 0 2.2u
R83 0 Net-_LED20-K_ 240
DLED20 Net-_LED20-K_ +3.3V LED_D_G
C93 +5V 0 10u
C100 +3.3V 0 10u
C16 NET0095 0 10p
C111 Net-_C111-Pad1_ 0 10p
R9 NET0075 Net-_C111-Pad1_ 620
C86 +3V3 0 100n
C106 +3V3 0 100n
R76 +3V3 NET0120 4.7k
R65 +3V3 NET0048 4.7k
R22 +3V3 NET0039 4.7k
R71 +3V3 NET0163 4.7k
C57 +3V3 0 100n
C70 +3V3 0 100n
DLED11 Net-_LED11-K_ NET0103 LED_D_B
R28 0 Net-_LED11-K_ 100
R52 +3V3 NET0115 4.7k
R38 +3V3 NET0065 4.7k
C38 VREF+_FCC 0 100n
R90 VREF+_FCC VDDA_FCC 47
C99 VDDA_FCC 0 100n
R73 0 Net-_LED12-K_ 330
R14 0 Net-_LED18-K_ 330
DLED3 Net-_LED3-K_ NET0139 LED_D_B
R62 0 Net-_LED3-K_ 100
C104 NET0171 0 100n
R89 0 Net-_LED1-K_ 330
DLED16 Net-_LED16-K_ NET0117 LED_D_B
DLED1 Net-_LED1-K_ NET0097 LED_D_Y
R63 0 Net-_LED16-K_ 100
DLED12 Net-_LED12-K_ NET0026 LED_D_R
DLED18 Net-_LED18-K_ NET0057 LED_D_R
C54 +3V3 0 100n
C89 +3V3 0 100n
C6 +3V3 0 100n
C69 +3V3 0 100n
C65 +3V3 0 100n
C30 +3V3 0 100n
C102 +3V3 0 100n
C18 Net-_FCC2-PH0_ 0 2.2u
C33 unconnected-_C33-Pad1_ 0 2.2u
R23 Net-_SW5-C_ NET0061 10k
R46 NET0154 Net-_C77-Pad1_ 620
C77 Net-_C77-Pad1_ 0 10p
C1 NET0094 0 10p
R18 +3V3 NET0035 4.7k
R24 +3V3 NET0013 4.7k
R54 +3V3 NET0028 4.7k
R48 +3V3 NET0021 4.7k
DLED2 Net-_LED2-K_ NET0060 LED_D_Y
DLED10 Net-_LED10-K_ NET0155 LED_D_B
R12 0 Net-_LED2-K_ 330
R55 0 Net-_LED10-K_ 100
DLED22 Net-_LED22-K_ NET0108 LED_D_R
R35 0 Net-_LED22-K_ 330
DLED7 Net-_LED7-K_ NET0123 LED_D_R
R6 0 Net-_LED7-K_ 330
C21 Net-_NAVC2-PH1_ 0 2.2u
C26 Net-_NAVC2-PH0_ 0 2.2u
C91 +3V3 0 100n
C55 +3V3 0 100n
C78 VDDA_NAVC 0 100n
C24 +3V3 0 100n
C76 +3V3 0 100n
C48 +3V3 0 100n
C64 +3V3 0 100n
C61 +3V3 0 100n
C75 +3V3 0 100n
C96 +3V3 0 100n
R47 Net-_SW1-C_ NET0051 10k
C31 NET0126 0 100n
R64 Net-_SW3-C_ NET0160 10k
R42 NET0056 NET0141 10
R72 NET0156 NET0101 10
R68 NET0169 NET0167 10
R16 NET0063 NET0176 10
R79 NET0145 NET0007 10
R34 NET0153 NET0138 10
R4 NET0093 NET0135 10
R21 NET0105 NET0168 10
R45 NET0040 Net-_USB2-D-_ 22
R69 NET0088 Net-_USB2-ID_ 560
R40 NET0092 Net-_USB2-D+_ 22
R20 NET0024 Net-_USB6-D+_ 22
R19 NET0067 Net-_USB6-D-_ 22
R2 NET0034 Net-_USB6-ID_ 560
C11 0 unconnected-_C11-Pad2_ 100n
C39 0 Net-_D5-A_ 100n
DLED5 Net-_LED5-K_ Net-_D5-A_ LED_D_G
R1 0 Net-_LED5-K_ 560
C84 0 unconnected-_C84-Pad2_ 100n
C58 0 Net-_D8-A_ 100n
DLED21 Net-_LED21-K_ Net-_D8-A_ LED_D_G
R5 0 Net-_LED21-K_ 560
R39 NET0121 NET0177 10
R82 NET0020 NET0173 10
R88 NET0066 NET0048 0
R25 NET0019 NET0163 0
C62 +3.3V 0 100n
R41 +3.3V Net-_U2-_WP__IO2__ 10k
R51 +3.3V Net-_U2-_HOLD__IO3__ 10k
C51 0 +3.3V 100n
C34 +3.3V 0 100n
C66 +3.3V 0 100n
C32 +3.3V 0 100n
C36 +3.3V 0 1u
C10 +3.3V 0 1u
C12 +3.3V 0 100n
C103 +3.3V 0 100n
C15 Net-_U7-C1_ 0 220n
R86 +3.3V NET0085 10k
C3 +3.3V 0 10u
R36 Net-_L3-Pad1_ Net-_U5-VCC_RF_ 10
C17 Net-_ANT2-Pad1_ Net-_U5-RF_IN_ 22p
C37 Net-_ANT2-Pad1_ 0 10n
L3 Net-_L3-Pad1_ Net-_ANT2-Pad1_ 27n
C60 +3.3V 0 100n
C40 +3.3V 0 100n
C47 Net-_U8-VO-_ Net-_U8-VO+_ 1n
C25 +3.3V 0 100n
R11 +3.3V NET0151 10k

V_3_3V +3.3V 0 DC 3.3
V_3V3 +3V3 0 DC 3.3
V_5V +5V 0 DC 5.0

.control
tran 100u 10m
set filetype=ascii
write Hades_raw.raw all
.endc

.end
