.title KiCad schematic

.model LED_D_G D (Is=1p Rs=10 N=1.7)
.model LED_D_B D (Is=1p Rs=10 N=1.7)
.model LED_D_Y D (Is=1p Rs=10 N=1.7)
.model LED_D_R D (Is=1p Rs=10 N=1.7)

R65 NET0050 VIN+ 0.01
C35 +3.3V 0 100n
C102 +5V NET0158 4.7n
L3 NET0084 +5V 15u
R49 +5V NET0158 6.8k
C40 +5V 0 47u
C103 +5V 0 100u
C37 NET0084 Net-_C37-Pad2_ 100n
R31 0 NET0158 1.3k
R75 Net-_C37-Pad2_ NET0158 19.6k
C66 NET0084 NET0150 100n
DLED2 Net-_LED2-K_ +5V LED_D_G
R85 0 Net-_LED2-K_ 560
R54 NET0097 Net-_D8-A_ 10k
C59 Net-_D8-A_ 0 2.2u
C99 Net-_REG2-PVDD_ 0 2.2u
R25 NET0050 NET0136 10k
C11 NET0050 0 100u
C30 NET0050 0 47u
R66 0 Net-_LED4-K_ 240
DLED4 Net-_LED4-K_ +3.3V LED_D_G
C3 +5V 0 10u
C100 +3.3V 0 10u
C93 NET0147 0 10p
C94 Net-_C94-Pad1_ 0 10p
R38 NET0148 Net-_C94-Pad1_ 620
C15 +3V3 0 100n
C14 +3V3 0 100n
R44 +3V3 NET0047 4.7k
R20 +3V3 NET0034 4.7k
R76 +3V3 NET0112 4.7k
R40 +3V3 NET0032 4.7k
C43 +3V3 0 100n
C26 +3V3 0 100n
DLED11 Net-_LED11-K_ NET0161 LED_D_B
R88 0 Net-_LED11-K_ 100
R37 +3V3 NET0132 4.7k
R45 +3V3 NET0007 4.7k
C98 VREF+_FCC 0 100n
R58 VREF+_FCC VDDA_FCC 47
C16 VDDA_FCC 0 100n
R21 0 Net-_LED18-K_ 330
R19 0 Net-_LED14-K_ 330
DLED6 Net-_LED6-K_ NET0165 LED_D_B
R94 0 Net-_LED6-K_ 100
C55 NET0082 0 100n
R48 0 Net-_LED8-K_ 330
DLED16 Net-_LED16-K_ NET0143 LED_D_B
DLED8 Net-_LED8-K_ NET0024 LED_D_Y
R27 0 Net-_LED16-K_ 100
DLED18 Net-_LED18-K_ NET0118 LED_D_R
DLED14 Net-_LED14-K_ NET0085 LED_D_R
C48 +3V3 0 100n
C28 +3V3 0 100n
C6 +3V3 0 100n
C69 +3V3 0 100n
C54 +3V3 0 100n
C101 +3V3 0 100n
C1 +3V3 0 100n
C42 Net-_FCC2-PH0_ 0 2.2u
C74 unconnected-_C74-Pad1_ 0 2.2u
R11 Net-_SW1-C_ NET0079 10k
R12 NET0036 Net-_C82-Pad1_ 620
C82 Net-_C82-Pad1_ 0 10p
C56 NET0078 0 10p
R63 +3V3 NET0057 4.7k
R87 +3V3 NET0025 4.7k
R4 +3V3 NET0109 4.7k
R22 +3V3 NET0092 4.7k
DLED17 Net-_LED17-K_ NET0167 LED_D_Y
DLED21 Net-_LED21-K_ NET0062 LED_D_B
R32 0 Net-_LED17-K_ 330
R91 0 Net-_LED21-K_ 100
DLED9 Net-_LED9-K_ NET0100 LED_D_R
R29 0 Net-_LED9-K_ 330
DLED5 Net-_LED5-K_ NET0046 LED_D_R
R30 0 Net-_LED5-K_ 330
C79 Net-_NAVC2-PH1_ 0 2.2u
C18 Net-_NAVC2-PH0_ 0 2.2u
C10 +3V3 0 100n
C67 +3V3 0 100n
C41 VDDA_NAVC 0 100n
C92 +3V3 0 100n
C106 +3V3 0 100n
C5 +3V3 0 100n
C50 +3V3 0 100n
C36 +3V3 0 100n
C81 +3V3 0 100n
C21 +3V3 0 100n
R1 Net-_SW8-C_ NET0006 10k
C27 NET0120 0 100n
R41 Net-_SW7-C_ NET0077 10k
R73 NET0076 NET0030 10
R57 NET0131 NET0170 10
R47 NET0098 NET0018 10
R3 NET0065 NET0162 10
R89 NET0155 NET0013 10
R62 NET0041 NET0060 10
R15 NET0128 NET0033 10
R53 NET0163 NET0149 10
R59 NET0111 Net-_USB6-D-_ 22
R60 NET0048 Net-_USB6-ID_ 560
R26 NET0142 Net-_USB6-D+_ 22
R74 NET0019 Net-_USB1-D+_ 22
R39 NET0124 Net-_USB1-D-_ 22
R43 NET0056 Net-_USB1-ID_ 560
DLED12 Net-_LED12-K_ Net-_D3-A_ LED_D_G
R46 0 Net-_LED12-K_ 560
C57 0 Net-_D3-A_ 100n
R83 0 Net-_LED1-K_ 560
DLED1 Net-_LED1-K_ Net-_D2-A_ LED_D_G
C105 0 Net-_D2-A_ 100n
R93 NET0101 NET0034 0
R24 NET0133 NET0032 0
R8 NET0129 NET0023 10
R52 NET0095 NET0010 10
C73 0 unconnected-_C73-Pad2_ 100n
C20 0 unconnected-_C20-Pad2_ 100n
C52 +3.3V 0 100n
R33 +3.3V Net-_U14-_WP__IO2__ 10k
R36 +3.3V Net-_U14-_HOLD__IO3__ 10k
C32 0 +3.3V 100n
C113 +3.3V 0 100n
C34 +3.3V 0 100n
C96 +3.3V 0 100n
C4 +3.3V 0 1u
C83 +3.3V 0 1u
C44 +3.3V 0 100n
C29 +3.3V 0 100n
C31 Net-_U1-C1_ 0 220n
R35 +3.3V NET0001 10k
C80 +3.3V 0 10u
R90 Net-_L1-Pad1_ Net-_U17-VCC_RF_ 10
C2 Net-_ANT2-Pad1_ Net-_U17-RF_IN_ 22p
C61 Net-_ANT2-Pad1_ 0 10n
L1 Net-_L1-Pad1_ Net-_ANT2-Pad1_ 27n
C64 +3.3V 0 100n
C53 +3.3V 0 100n
C86 Net-_U16-VO-_ Net-_U16-VO+_ 1n
C23 +3.3V 0 100n
R71 +3.3V NET0144 10k

V_3_3V +3.3V 0 DC 3.3
V_3V3 +3V3 0 DC 3.3
V_5V +5V 0 DC 5.0

.control
tran 100u 10m
set filetype=ascii
write Hades_raw.raw all
.endc

.end
