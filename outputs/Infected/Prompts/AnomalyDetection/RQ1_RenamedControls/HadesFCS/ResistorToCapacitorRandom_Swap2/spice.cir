.title KiCad schematic

.model LED_D_G D (Is=1p Rs=10 N=1.7)
.model LED_D_B D (Is=1p Rs=10 N=1.7)
.model LED_D_Y D (Is=1p Rs=10 N=1.7)
.model LED_D_R D (Is=1p Rs=10 N=1.7)

R36 NET0177 VIN+ 0.01
C7 +3.3V 0 100n
C99 +5V NET0021 4.7n
L3 NET0090 +5V 15u
R55 +5V NET0021 6.8k
C87 +5V 0 47u
C82 +5V 0 100u
C61 NET0090 Net-_C61-Pad2_ 100n
R53 0 NET0021 1.3k
R5 Net-_C61-Pad2_ NET0021 19.6k
C34 NET0090 NET0017 100n
DLED16 Net-_LED16-K_ +5V LED_D_G
R59 0 Net-_LED16-K_ 560
R37 NET0047 Net-_D7-A_ 10k
C55 Net-_D7-A_ 0 2.2u
C36 NET0177 0 100u
C105 NET0177 0 47u
R28 NET0177 NET0065 10k
C17 Net-_REG2-PVDD_ 0 2.2u
R32 0 Net-_LED9-K_ 240
DLED9 Net-_LED9-K_ +3.3V LED_D_G
C84 +5V 0 10u
C6 +3.3V 0 10u
C91 NET0020 0 10p
C71 Net-_C71-Pad1_ 0 10p
R26 NET0075 Net-_C71-Pad1_ 620
C8 +3V3 0 100n
C73 +3V3 0 100n
R12 +3V3 NET0144 4.7k
R51 +3V3 NET0096 4.7k
R83 +3V3 NET0137 4.7k
R49 +3V3 NET0138 4.7k
C81 +3V3 0 100n
C65 +3V3 0 100n
DLED7 Net-_LED7-K_ NET0167 LED_D_B
R47 0 Net-_LED7-K_ 100
R61 +3V3 NET0043 4.7k
R16 +3V3 NET0139 4.7k
C23 VREF+_FCC 0 100n
R68 VREF+_FCC VDDA_FCC 47
C27 VDDA_FCC 0 100n
R38 0 Net-_LED15-K_ 330
R1 0 Net-_LED8-K_ 330
DLED21 Net-_LED21-K_ NET0133 LED_D_B
R40 0 Net-_LED21-K_ 100
C56 NET0100 0 100n
R20 0 Net-_LED11-K_ 330
DLED3 Net-_LED3-K_ NET0154 LED_D_B
DLED11 Net-_LED11-K_ NET0102 LED_D_Y
R74 0 Net-_LED3-K_ 100
DLED15 Net-_LED15-K_ NET0168 LED_D_R
DLED8 Net-_LED8-K_ NET0136 LED_D_R
C77 +3V3 0 100n
C5 +3V3 0 100n
C59 +3V3 0 100n
C40 +3V3 0 100n
C13 +3V3 0 100n
C2 +3V3 0 100n
C106 +3V3 0 100n
C16 Net-_FCC2-PH0_ 0 2.2u
C33 unconnected-_C33-Pad1_ 0 2.2u
R19 Net-_SW3-C_ NET0151 10k
R88 NET0120 Net-_C85-Pad1_ 620
C85 Net-_C85-Pad1_ 0 10p
C45 NET0112 0 10p
R63 +3V3 NET0030 4.7k
R6 +3V3 NET0033 4.7k
R39 +3V3 NET0074 4.7k
R10 +3V3 NET0124 4.7k
DLED19 Net-_LED19-K_ NET0053 LED_D_Y
DLED1 Net-_LED1-K_ NET0121 LED_D_B
R94 0 Net-_LED19-K_ 330
R30 0 Net-_LED1-K_ 100
DLED13 Net-_LED13-K_ NET0158 LED_D_R
R24 0 Net-_LED13-K_ 330
DLED6 Net-_LED6-K_ NET0003 LED_D_R
R41 0 Net-_LED6-K_ 330
C108 Net-_NAVC2-PH1_ 0 2.2u
C79 Net-_NAVC2-PH0_ 0 2.2u
C93 +3V3 0 100n
C113 +3V3 0 100n
C69 VDDA_NAVC 0 100n
C60 +3V3 0 100n
C10 +3V3 0 100n
C68 +3V3 0 100n
C66 +3V3 0 100n
C1 +3V3 0 100n
C57 +3V3 0 100n
C24 +3V3 0 100n
R91 Net-_SW2-C_ NET0132 10k
C72 NET0174 0 100n
R8 Net-_SW7-C_ NET0162 10k
R48 NET0106 NET0060 10
R86 NET0005 NET0076 10
R17 NET0044 NET0038 10
R23 NET0063 NET0042 10
R89 NET0104 NET0071 10
R79 NET0034 NET0035 10
R85 NET0087 NET0029 10
R9 NET0002 NET0069 10
R31 NET0048 Net-_USB3-D-_ 22
R69 NET0085 Net-_USB3-ID_ 560
R54 NET0123 Net-_USB3-D+_ 22
R45 NET0050 Net-_USB4-D+_ 22
R73 NET0092 Net-_USB4-D-_ 22
R34 NET0026 Net-_USB4-ID_ 560
DLED12 Net-_LED12-K_ Net-_D5-A_ LED_D_G
R2 0 Net-_LED12-K_ 560
C78 0 Net-_D5-A_ 100n
R82 0 Net-_LED17-K_ 560
DLED17 Net-_LED17-K_ Net-_D4-A_ LED_D_G
C15 0 Net-_D4-A_ 100n
R52 NET0101 NET0096 0
R21 NET0073 NET0138 0
R70 NET0057 NET0027 10
R72 NET0001 NET0119 10
C109 0 unconnected-_C109-Pad2_ 100n
C97 0 unconnected-_C97-Pad2_ 100n
C42 +3.3V 0 100n
R87 +3.3V Net-_U17-_WP__IO2__ 10k
R65 +3.3V Net-_U17-_HOLD__IO3__ 10k
C100 0 +3.3V 100n
C112 +3.3V 0 100n
C37 +3.3V 0 100n
C30 +3.3V 0 100n
C111 +3.3V 0 1u
C88 +3.3V 0 1u
C86 +3.3V 0 100n
C48 +3.3V 0 100n
C52 Net-_U19-C1_ 0 220n
R78 +3.3V NET0172 10k
C49 +3.3V 0 10u
R7 Net-_L1-Pad1_ Net-_U7-VCC_RF_ 10
C75 Net-_ANT2-Pad1_ Net-_U7-RF_IN_ 22p
C70 Net-_ANT2-Pad1_ 0 10n
L1 Net-_L1-Pad1_ Net-_ANT2-Pad1_ 27n
C53 +3.3V 0 100n
C98 +3.3V 0 100n
C47 Net-_U14-VO-_ Net-_U14-VO+_ 1n
C63 +3.3V 0 100n
R81 +3.3V NET0024 10k

V_3_3V +3.3V 0 DC 3.3
V_3V3 +3V3 0 DC 3.3
V_5V +5V 0 DC 5.0

.control
tran 100u 10m
set filetype=ascii
write Hades_raw.raw all
.endc

.end
