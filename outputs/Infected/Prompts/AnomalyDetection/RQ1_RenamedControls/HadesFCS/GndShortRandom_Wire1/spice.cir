.title KiCad schematic

.model LED_D_G D (Is=1p Rs=10 N=1.7)
.model LED_D_B D (Is=1p Rs=10 N=1.7)
.model LED_D_Y D (Is=1p Rs=10 N=1.7)
.model LED_D_R D (Is=1p Rs=10 N=1.7)

R21 NET0175 VIN+ 0.01
C95 +3.3V 0 100n
C9 +5V NET0136 4.7n
L2 NET0005 +5V 15u
R55 +5V NET0136 6.8k
C40 +5V 0 47u
C35 +5V 0 100u
C91 NET0005 Net-_C91-Pad2_ 100n
R40 0 NET0136 1.3k
R62 Net-_C91-Pad2_ NET0136 19.6k
C105 NET0005 NET0035 100n
DLED14 Net-_LED14-K_ +5V LED_D_G
R32 0 Net-_LED14-K_ 560
R31 NET0133 Net-_D7-A_ 10k
C69 Net-_D7-A_ 0 2.2u
C33 Net-_REG3-PVDD_ 0 2.2u
R3 NET0175 NET0159 10k
C112 NET0175 0 100u
C70 NET0175 0 47u
R54 0 Net-_LED15-K_ 240
DLED15 Net-_LED15-K_ +3.3V LED_D_G
C63 +5V 0 10u
C75 +3.3V 0 10u
C49 NET0080 0 10p
C58 Net-_C58-Pad1_ 0 10p
R13 NET0116 Net-_C58-Pad1_ 620
C11 +3V3 0 100n
C107 +3V3 0 100n
R38 +3V3 NET0112 4.7k
R82 +3V3 NET0093 4.7k
R49 +3V3 NET0077 4.7k
R93 +3V3 NET0032 4.7k
C73 +3V3 0 100n
C79 +3V3 0 100n
DLED13 Net-_LED13-K_ NET0127 LED_D_B
R77 0 Net-_LED13-K_ 100
R85 +3V3 NET0084 4.7k
R4 +3V3 NET0030 4.7k
C67 VREF+_FCC 0 100n
R15 VREF+_FCC VDDA_FCC 47
C90 VDDA_FCC 0 100n
R91 0 Net-_LED12-K_ 330
R53 0 Net-_LED21-K_ 330
DLED20 Net-_LED20-K_ NET0105 LED_D_B
R1 0 Net-_LED20-K_ 100
C20 NET0011 0 100n
R28 0 Net-_LED17-K_ 330
DLED9 Net-_LED9-K_ NET0086 LED_D_B
DLED17 Net-_LED17-K_ NET0068 LED_D_Y
R25 0 Net-_LED9-K_ 100
DLED12 Net-_LED12-K_ NET0040 LED_D_R
DLED21 Net-_LED21-K_ NET0176 LED_D_R
C72 +3V3 0 100n
C45 +3V3 0 100n
C88 +3V3 0 100n
C102 +3V3 0 100n
C22 +3V3 0 100n
C42 +3V3 0 100n
C98 +3V3 0 100n
C1 Net-_FCC2-PH0_ 0 2.2u
C96 unconnected-_C96-Pad1_ 0 2.2u
R44 Net-_SW4-C_ NET0082 10k
R67 NET0072 Net-_C46-Pad1_ 620
C46 Net-_C46-Pad1_ 0 10p
C28 NET0034 0 10p
R12 +3V3 NET0154 4.7k
R10 +3V3 NET0161 4.7k
R6 +3V3 NET0121 4.7k
R5 +3V3 NET0054 4.7k
DLED10 Net-_LED10-K_ NET0128 LED_D_Y
DLED11 Net-_LED11-K_ NET0036 LED_D_B
R71 0 Net-_LED10-K_ 330
R78 0 Net-_LED11-K_ 100
DLED7 Net-_LED7-K_ NET0025 LED_D_R
R42 0 Net-_LED7-K_ 330
DLED3 Net-_LED3-K_ NET0110 LED_D_R
R83 0 Net-_LED3-K_ 330
C93 Net-_NAVC2-PH1_ 0 2.2u
C76 Net-_NAVC2-PH0_ 0 2.2u
C86 +3V3 0 100n
C5 +3V3 0 100n
C10 VDDA_NAVC 0 100n
C74 +3V3 0 100n
C4 +3V3 0 100n
C13 +3V3 0 100n
C7 +3V3 0 100n
C51 +3V3 0 100n
C106 +3V3 0 100n
C84 +3V3 0 100n
R75 Net-_SW5-C_ NET0172 10k
C38 NET0046 0 100n
R8 Net-_SW6-C_ NET0094 10k
R74 NET0167 NET0088 10
R72 NET0039 NET0102 10
R20 NET0155 NET0140 10
R14 NET0152 NET0126 10
R11 NET0147 NET0064 10
R76 NET0123 NET0163 10
R87 NET0149 NET0028 10
R41 NET0138 NET0130 10
R68 NET0024 Net-_USB2-D-_ 22
R60 NET0075 Net-_USB2-ID_ 560
R30 NET0073 Net-_USB2-D+_ 22
R36 NET0103 Net-_USB4-D+_ 22
R66 NET0092 Net-_USB4-D-_ 22
R7 NET0120 Net-_USB4-ID_ 560
DLED22 Net-_LED22-K_ Net-_D3-A_ LED_D_G
R73 0 Net-_LED22-K_ 560
C14 0 Net-_D3-A_ 100n
R61 0 Net-_LED1-K_ 560
DLED1 Net-_LED1-K_ Net-_D4-A_ LED_D_G
C25 0 Net-_D4-A_ 100n
R24 NET0115 NET0093 0
R34 NET0008 NET0032 0
R39 NET0070 NET0153 10
R79 NET0173 NET0168 10
C87 0 unconnected-_C87-Pad2_ 100n
C97 0 unconnected-_C97-Pad2_ 100n
C12 +3.3V 0 100n
R16 +3.3V Net-_U1-_WP__IO2__ 10k
R51 +3.3V Net-_U1-_HOLD__IO3__ 10k
C26 0 +3.3V 100n
C80 +3.3V 0 100n
C53 +3.3V 0 100n
C44 +3.3V 0 100n
C83 +3.3V 0 1u
C18 +3.3V 0 1u
C23 +3.3V 0 100n
C92 +3.3V 0 100n
C55 Net-_U6-C1_ 0 220n
R22 +3.3V NET0099 10k
C77 +3.3V 0 10u
R59 Net-_L3-Pad1_ Net-_U11-VCC_RF_ 10
C62 Net-_ANT2-Pad1_ Net-_U11-RF_IN_ 22p
C37 Net-_ANT2-Pad1_ 0 10n
L3 Net-_L3-Pad1_ Net-_ANT2-Pad1_ 27n
C54 +3.3V 0 100n
C99 +3.3V 0 100n
C21 Net-_U8-VO-_ Net-_U8-VO+_ 1n
C17 +3.3V 0 100n
R47 +3.3V NET0004 10k

V_3_3V +3.3V 0 DC 3.3
V_3V3 +3V3 0 DC 3.3
V_5V +5V 0 DC 5.0

.control
tran 100u 10m
set filetype=ascii
write Hades_raw.raw all
.endc

.end
