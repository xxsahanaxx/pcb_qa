.title KiCad schematic

.model LED_D_G D (Is=1p Rs=10 N=1.7)
.model LED_D_B D (Is=1p Rs=10 N=1.7)
.model LED_D_Y D (Is=1p Rs=10 N=1.7)
.model LED_D_R D (Is=1p Rs=10 N=1.7)

R66 NET0064 VIN+ 0.01
C83 +3.3V 0 100n
C53 +5V NET0143 4.7n
L3 NET0093 +5V 15u
R19 +5V NET0143 6.8k
C65 +5V 0 47u
C74 +5V 0 100u
C60 NET0093 Net-_C60-Pad2_ 100n
R17 0 NET0143 1.3k
R92 Net-_C60-Pad2_ NET0143 19.6k
C64 NET0093 NET0101 100n
DLED6 Net-_LED6-K_ +5V LED_D_G
R53 0 Net-_LED6-K_ 560
R52 NET0047 Net-_D2-A_ 10k
C91 Net-_D2-A_ 0 2.2u
C54 Net-_REG3-PVDD_ 0 2.2u
R63 NET0064 NET0162 10k
C15 NET0064 0 100u
C12 NET0064 0 47u
R25 0 Net-_LED11-K_ 240
DLED11 Net-_LED11-K_ +3.3V LED_D_G
C98 +5V 0 10u
C10 +3.3V 0 10u
C113 NET0097 0 10p
C78 Net-_C78-Pad1_ 0 10p
R3 NET0073 Net-_C78-Pad1_ 620
C24 +3V3 0 100n
C76 +3V3 0 100n
R65 +3V3 NET0103 4.7k
R49 +3V3 NET0034 4.7k
R34 +3V3 NET0102 4.7k
R46 +3V3 NET0155 4.7k
C81 +3V3 0 100n
C45 +3V3 0 100n
DLED17 Net-_LED17-K_ NET0043 LED_D_B
R16 0 Net-_LED17-K_ 100
R48 +3V3 NET0046 4.7k
R50 +3V3 NET0146 4.7k
C34 VREF+_FCC 0 100n
R86 VREF+_FCC VDDA_FCC 47
C88 VDDA_FCC 0 100n
R54 0 Net-_LED12-K_ 330
R8 0 Net-_LED13-K_ 330
DLED18 Net-_LED18-K_ NET0127 LED_D_B
R72 0 Net-_LED18-K_ 100
C14 NET0124 0 100n
R1 0 Net-_LED19-K_ 330
DLED7 Net-_LED7-K_ NET0119 LED_D_B
DLED19 Net-_LED19-K_ NET0035 LED_D_Y
R15 0 Net-_LED7-K_ 100
DLED12 Net-_LED12-K_ NET0154 LED_D_R
DLED13 Net-_LED13-K_ NET0174 LED_D_R
C75 +3V3 0 100n
C72 +3V3 0 100n
C52 +3V3 0 100n
C87 +3V3 0 100n
C101 +3V3 0 100n
C1 +3V3 0 100n
C103 +3V3 0 100n
C66 Net-_FCC2-PH0_ 0 2.2u
C4 unconnected-_C4-Pad1_ 0 2.2u
R55 Net-_SW6-C_ NET0030 10k
R87 NET0165 Net-_C96-Pad1_ 620
C96 Net-_C96-Pad1_ 0 10p
C44 NET0100 0 10p
R27 +3V3 NET0010 4.7k
R10 +3V3 NET0168 4.7k
R85 +3V3 NET0074 4.7k
R12 +3V3 NET0150 4.7k
DLED20 Net-_LED20-K_ NET0028 LED_D_Y
DLED16 Net-_LED16-K_ NET0078 LED_D_B
R22 0 Net-_LED20-K_ 330
R21 0 Net-_LED16-K_ 100
DLED21 Net-_LED21-K_ NET0161 LED_D_R
R26 0 Net-_LED21-K_ 330
DLED8 Net-_LED8-K_ NET0059 LED_D_R
R93 0 Net-_LED8-K_ 330
C57 Net-_NAVC2-PH1_ 0 2.2u
C21 Net-_NAVC2-PH0_ 0 2.2u
C37 +3V3 0 100n
C80 +3V3 0 100n
C110 VDDA_NAVC 0 100n
C92 +3V3 0 100n
C27 +3V3 0 100n
C25 +3V3 0 100n
C112 +3V3 0 100n
C30 +3V3 0 100n
C93 +3V3 0 100n
C48 +3V3 0 100n
R41 Net-_SW7-C_ NET0029 10k
C85 NET0113 0 100n
R35 Net-_SW5-C_ NET0169 10k
R31 NET0152 NET0067 10
R82 NET0142 NET0021 10
R81 NET0063 NET0080 10
R56 NET0026 NET0144 10
R38 NET0110 NET0153 10
R51 NET0133 NET0140 10
R91 NET0040 NET0052 10
R4 NET0037 NET0095 10
R20 NET0108 Net-_USB4-D-_ 22
R29 NET0062 Net-_USB4-ID_ 560
R11 NET0166 Net-_USB4-D+_ 22
R76 NET0044 Net-_USB1-D+_ 22
R94 NET0148 Net-_USB1-D-_ 22
R60 NET0031 Net-_USB1-ID_ 560
C102 0 unconnected-_C102-Pad2_ 100n
C36 0 Net-_D3-A_ 100n
DLED3 Net-_LED3-K_ Net-_D3-A_ LED_D_G
R84 0 Net-_LED3-K_ 560
C79 0 unconnected-_C79-Pad2_ 100n
C62 0 Net-_D1-A_ 100n
DLED5 Net-_LED5-K_ Net-_D1-A_ LED_D_G
R43 0 Net-_LED5-K_ 560
R59 NET0121 NET0107 10
R78 NET0006 NET0075 10
R68 NET0038 NET0034 0
R13 NET0084 NET0155 0
C32 +3.3V 0 100n
R39 +3.3V Net-_U2-_WP__IO2__ 10k
R64 +3.3V Net-_U2-_HOLD__IO3__ 10k
C9 0 +3.3V 100n
C67 +3.3V 0 100n
C11 +3.3V 0 100n
C69 +3.3V 0 100n
C108 +3.3V 0 1u
C90 +3.3V 0 1u
C39 +3.3V 0 100n
C31 +3.3V 0 100n
C95 Net-_U17-C1_ 0 220n
R37 +3.3V NET0025 10k
C43 +3.3V 0 10u
R7 Net-_L1-Pad1_ Net-_U11-VCC_RF_ 10
C22 Net-_ANT2-Pad1_ Net-_U11-RF_IN_ 22p
C109 Net-_ANT2-Pad1_ 0 10n
L1 Net-_L1-Pad1_ Net-_ANT2-Pad1_ 27n
C41 +3.3V 0 100n
C49 +3.3V 0 100n
C107 Net-_U10-VO-_ Net-_U10-VO+_ 1n
C105 +3.3V 0 100n
R58 +3.3V NET0022 10k

V_3_3V +3.3V 0 DC 3.3
V_3V3 +3V3 0 DC 3.3
V_5V +5V 0 DC 5.0

.control
tran 100u 10m
set filetype=ascii
write Hades_raw.raw all
.endc

.end
