.title KiCad schematic

.model LED_D_G D (Is=1p Rs=10 N=1.7)
.model LED_D_B D (Is=1p Rs=10 N=1.7)
.model LED_D_Y D (Is=1p Rs=10 N=1.7)
.model LED_D_R D (Is=1p Rs=10 N=1.7)

R4 NET0163 VIN+ 0.01
C55 +3.3V 0 100n
C40 +5V NET0176 4.7n
L2 NET0147 +5V 15u
R15 +5V NET0176 6.8k
C19 +5V 0 47u
C98 +5V 0 100u
C7 NET0147 Net-_C7-Pad2_ 100n
R85 0 NET0176 1.3k
R6 Net-_C7-Pad2_ NET0176 19.6k
C43 NET0147 NET0123 100n
DLED9 Net-_LED9-K_ +5V LED_D_G
R65 0 Net-_LED9-K_ 560
R71 NET0118 Net-_D2-A_ 10k
C44 Net-_D2-A_ 0 2.2u
C106 Net-_REG2-PVDD_ 0 2.2u
R22 NET0163 NET0067 10k
C59 NET0163 0 100u
C83 NET0163 0 47u
R11 0 Net-_LED14-K_ 240
DLED14 Net-_LED14-K_ +3.3V LED_D_G
C72 +5V 0 10u
C27 +3.3V 0 10u
C100 NET0116 0 10p
C73 Net-_C73-Pad1_ 0 10p
R52 NET0175 Net-_C73-Pad1_ 620
C17 +3V3 0 100n
C15 +3V3 0 100n
R48 +3V3 NET0167 4.7k
R14 +3V3 NET0025 4.7k
R62 +3V3 NET0165 4.7k
C107 +3V3 0 100n
R5 +3V3 NET0113 4.7k
C63 +3V3 0 100n
DLED18 Net-_LED18-K_ NET0154 LED_D_B
R28 0 Net-_LED18-K_ 100
R1 +3V3 NET0055 4.7k
R10 +3V3 NET0008 4.7k
C42 VREF+_FCC 0 100n
R34 VREF+_FCC VDDA_FCC 47
C47 VDDA_FCC 0 100n
R70 0 Net-_LED22-K_ 330
R43 0 Net-_LED8-K_ 330
DLED5 Net-_LED5-K_ NET0053 LED_D_B
R50 0 Net-_LED5-K_ 100
C46 NET0024 0 100n
R41 0 Net-_LED17-K_ 330
DLED11 Net-_LED11-K_ NET0158 LED_D_B
DLED17 Net-_LED17-K_ NET0144 LED_D_Y
R7 0 Net-_LED11-K_ 100
DLED22 Net-_LED22-K_ NET0160 LED_D_R
DLED8 Net-_LED8-K_ NET0106 LED_D_R
C30 +3V3 0 100n
C2 +3V3 0 100n
C4 +3V3 0 100n
C10 +3V3 0 100n
C21 +3V3 0 100n
C70 +3V3 0 100n
C8 +3V3 0 100n
C66 Net-_FCC2-PH0_ 0 2.2u
C92 unconnected-_C92-Pad1_ 0 2.2u
R51 Net-_SW6-C_ NET0081 10k
R42 NET0141 Net-_C35-Pad1_ 620
C35 Net-_C35-Pad1_ 0 10p
C50 NET0166 0 10p
R29 +3V3 NET0078 4.7k
R18 +3V3 NET0003 4.7k
R84 +3V3 NET0052 4.7k
R39 +3V3 NET0005 4.7k
DLED7 Net-_LED7-K_ NET0088 LED_D_Y
DLED4 Net-_LED4-K_ NET0072 LED_D_B
R2 0 Net-_LED7-K_ 330
R83 0 Net-_LED4-K_ 100
DLED21 Net-_LED21-K_ NET0126 LED_D_R
R16 0 Net-_LED21-K_ 330
DLED10 Net-_LED10-K_ NET0095 LED_D_R
R92 0 Net-_LED10-K_ 330
C76 Net-_NAVC2-PH1_ 0 2.2u
C79 Net-_NAVC2-PH0_ 0 2.2u
C67 +3V3 0 100n
C52 +3V3 0 100n
C20 VDDA_NAVC 0 100n
C85 +3V3 0 100n
C18 +3V3 0 100n
C48 +3V3 0 100n
C23 +3V3 0 100n
C62 +3V3 0 100n
C88 +3V3 0 100n
C82 +3V3 0 100n
R72 Net-_SW8-C_ NET0029 10k
C89 NET0063 0 100n
R69 Net-_SW7-C_ NET0028 10k
R90 NET0135 NET0104 10
R94 NET0122 NET0098 10
R19 NET0094 NET0130 10
R80 NET0087 NET0017 10
R12 NET0111 NET0086 10
R79 NET0034 NET0006 10
R44 NET0014 NET0012 10
R49 NET0022 NET0036 10
R54 NET0172 Net-_USB2-D-_ 22
R74 NET0065 Net-_USB2-ID_ 560
R77 NET0016 Net-_USB2-D+_ 22
R89 NET0060 Net-_USB6-D+_ 22
R35 NET0177 Net-_USB6-D-_ 22
R58 NET0143 Net-_USB6-ID_ 560
DLED20 Net-_LED20-K_ Net-_D3-A_ LED_D_G
R23 0 Net-_LED20-K_ 560
C108 0 Net-_D3-A_ 100n
R56 0 Net-_LED6-K_ 560
DLED6 Net-_LED6-K_ Net-_D7-A_ LED_D_G
C28 0 Net-_D7-A_ 100n
R53 NET0047 NET0113 0
R9 NET0108 NET0165 0
R60 NET0021 NET0145 10
R24 NET0079 NET0023 10
C84 0 unconnected-_C84-Pad2_ 100n
C16 0 unconnected-_C16-Pad2_ 100n
C103 +3.3V 0 100n
R81 +3.3V Net-_U14-_WP__IO2__ 10k
R73 +3.3V Net-_U14-_HOLD__IO3__ 10k
C74 0 +3.3V 100n
C110 +3.3V 0 100n
C3 +3.3V 0 100n
C61 +3.3V 0 100n
C87 +3.3V 0 1u
C1 +3.3V 0 1u
C41 +3.3V 0 100n
C109 +3.3V 0 100n
C37 Net-_U4-C1_ 0 220n
R75 +3.3V NET0074 10k
C5 +3.3V 0 10u
R21 Net-_L3-Pad1_ Net-_U17-VCC_RF_ 10
C22 Net-_ANT2-Pad1_ Net-_U17-RF_IN_ 22p
C49 Net-_ANT2-Pad1_ 0 10n
L3 Net-_L3-Pad1_ Net-_ANT2-Pad1_ 27n
C26 +3.3V 0 100n
C94 +3.3V 0 100n
C12 Net-_U16-VO-_ Net-_U16-VO+_ 1n
C80 +3.3V 0 100n
R63 +3.3V NET0115 10k

V_3_3V +3.3V 0 DC 3.3
V_3V3 +3V3 0 DC 3.3
V_5V +5V 0 DC 5.0

.control
tran 100u 10m
set filetype=ascii
write Hades_raw.raw all
.endc

.end
