.title KiCad schematic

.model LED_D_G D (Is=1p Rs=10 N=1.7)
.model LED_D_B D (Is=1p Rs=10 N=1.7)
.model LED_D_Y D (Is=1p Rs=10 N=1.7)
.model LED_D_R D (Is=1p Rs=10 N=1.7)

R54 NET0034 VIN+ 0.01
C22 +3.3V 0 100n
C35 +5V NET0012 4.7n
L2 NET0107 +5V 15u
R46 +5V NET0012 6.8k
C54 +5V 0 47u
C112 +5V 0 100u
C2 NET0107 Net-_C2-Pad2_ 100n
R10 0 NET0012 1.3k
R9 Net-_C2-Pad2_ NET0012 19.6k
C15 NET0107 NET0056 100n
DLED13 Net-_LED13-K_ +5V LED_D_G
R29 0 Net-_LED13-K_ 560
R33 NET0177 Net-_D5-A_ 10k
C20 Net-_D5-A_ 0 2.2u
C32 Net-_REG2-PVDD_ 0 2.2u
R56 NET0034 NET0162 10k
C95 NET0034 0 100u
C65 NET0034 0 47u
R85 0 Net-_LED19-K_ 240
DLED19 Net-_LED19-K_ +3.3V LED_D_G
C19 +5V 0 10u
C60 +3.3V 0 10u
C14 NET0141 0 10p
C92 Net-_C92-Pad1_ 0 10p
R57 NET0089 Net-_C92-Pad1_ 620
C27 +3V3 0 100n
C13 +3V3 0 100n
R12 +3V3 NET0148 4.7k
R25 +3V3 NET0118 4.7k
R47 +3V3 NET0050 4.7k
R42 +3V3 NET0121 4.7k
C11 +3V3 0 100n
C40 +3V3 0 100n
DLED4 Net-_LED4-K_ NET0172 LED_D_B
R27 0 Net-_LED4-K_ 100
R36 +3V3 NET0131 4.7k
R81 +3V3 NET0165 4.7k
C98 VREF+_FCC 0 100n
R86 VREF+_FCC VDDA_FCC 47
C48 VDDA_FCC 0 100n
R77 0 Net-_LED5-K_ 330
R65 0 Net-_LED22-K_ 330
DLED14 Net-_LED14-K_ NET0091 LED_D_B
R37 0 Net-_LED14-K_ 100
C104 NET0019 0 100n
R35 0 Net-_LED3-K_ 330
DLED8 Net-_LED8-K_ NET0175 LED_D_B
DLED3 Net-_LED3-K_ NET0097 LED_D_Y
R91 0 Net-_LED8-K_ 100
DLED5 Net-_LED5-K_ NET0020 LED_D_R
DLED22 Net-_LED22-K_ NET0052 LED_D_R
C6 +3V3 0 100n
C70 +3V3 0 100n
C58 +3V3 0 100n
C84 +3V3 0 100n
C63 +3V3 0 100n
C85 +3V3 0 100n
C43 +3V3 0 100n
C34 Net-_FCC2-PH0_ 0 2.2u
C31 unconnected-_C31-Pad1_ 0 2.2u
R8 Net-_SW1-C_ NET0065 10k
R28 NET0094 Net-_C52-Pad1_ 620
C52 Net-_C52-Pad1_ 0 10p
C79 NET0017 0 10p
R74 +3V3 NET0145 4.7k
R66 +3V3 NET0174 4.7k
R93 +3V3 NET0119 4.7k
R89 +3V3 NET0049 4.7k
DLED18 Net-_LED18-K_ NET0014 LED_D_Y
DLED7 Net-_LED7-K_ NET0060 LED_D_B
R80 0 Net-_LED18-K_ 330
R63 0 Net-_LED7-K_ 100
DLED9 Net-_LED9-K_ NET0005 LED_D_R
R39 0 Net-_LED9-K_ 330
DLED2 Net-_LED2-K_ NET0037 LED_D_R
R53 0 Net-_LED2-K_ 330
C67 Net-_NAVC2-PH1_ 0 2.2u
C25 Net-_NAVC2-PH0_ 0 2.2u
C29 +3V3 0 100n
C41 +3V3 0 100n
C37 VDDA_NAVC 0 100n
C50 +3V3 0 100n
C107 +3V3 0 100n
C64 +3V3 0 100n
C59 +3V3 0 100n
C90 +3V3 0 100n
C111 +3V3 0 100n
C110 +3V3 0 100n
R40 Net-_SW2-C_ NET0024 10k
C91 NET0164 0 100n
R84 Net-_SW7-C_ NET0088 10k
R71 NET0033 NET0128 10
R21 NET0045 NET0040 10
R14 NET0004 NET0170 10
R87 NET0079 NET0084 10
R78 NET0039 NET0173 10
R15 NET0092 NET0157 10
R19 NET0117 NET0116 10
R26 NET0032 NET0075 10
R1 NET0142 Net-_USB4-D-_ 22
R11 NET0137 Net-_USB4-ID_ 560
R90 NET0122 Net-_USB4-D+_ 22
R48 NET0036 Net-_USB5-D+_ 22
R41 NET0152 Net-_USB5-D-_ 22
R64 NET0053 Net-_USB5-ID_ 560
DLED10 Net-_LED10-K_ Net-_D1-A_ LED_D_G
R69 0 Net-_LED10-K_ 560
C17 0 Net-_D1-A_ 100n
R88 0 Net-_LED17-K_ 560
DLED17 Net-_LED17-K_ Net-_D3-A_ LED_D_G
C51 0 Net-_D3-A_ 100n
R13 NET0048 NET0118 0
R30 NET0068 NET0121 0
R70 NET0010 NET0078 10
R50 NET0134 NET0021 10
C33 0 unconnected-_C33-Pad2_ 100n
C105 0 unconnected-_C105-Pad2_ 100n
C30 +3.3V 0 100n
R59 +3.3V Net-_U5-_WP__IO2__ 10k
R32 +3.3V Net-_U5-_HOLD__IO3__ 10k
C83 0 +3.3V 100n
C28 +3.3V 0 100n
C38 +3.3V 0 100n
C42 +3.3V 0 100n
C66 +3.3V 0 1u
C8 +3.3V 0 1u
C82 +3.3V 0 100n
C44 +3.3V 0 100n
C86 Net-_U12-C1_ 0 220n
R43 +3.3V NET0110 10k
C106 +3.3V 0 10u
R79 Net-_L1-Pad1_ Net-_U8-VCC_RF_ 10
C77 Net-_ANT2-Pad1_ Net-_U8-RF_IN_ 22p
C113 Net-_ANT2-Pad1_ 0 10n
L1 Net-_L1-Pad1_ Net-_ANT2-Pad1_ 27n
C99 +3.3V 0 100n
C96 +3.3V 0 100n
C1 Net-_U15-VO-_ Net-_U15-VO+_ 1n
C9 +3.3V 0 100n
R52 +3.3V NET0058 10k

V_3_3V +3.3V 0 DC 3.3
V_3V3 +3V3 0 DC 3.3
V_5V +5V 0 DC 5.0

.control
tran 100u 10m
set filetype=ascii
write Hades_raw.raw all
.endc

.end
