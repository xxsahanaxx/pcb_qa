.title KiCad schematic

.model LED_D_G D (Is=1p Rs=10 N=1.7)
.model LED_D_B D (Is=1p Rs=10 N=1.7)
.model LED_D_Y D (Is=1p Rs=10 N=1.7)
.model LED_D_R D (Is=1p Rs=10 N=1.7)

R41 NET0050 VIN+ 0.01
C8 +3.3V 0 100n
C80 +5V NET0028 4.7n
L2 NET0107 +5V 15u
R51 +5V NET0028 6.8k
C67 +5V 0 47u
C96 +5V 0 100u
C9 NET0107 Net-_C9-Pad2_ 100n
R62 0 NET0028 1.3k
R16 Net-_C9-Pad2_ NET0028 19.6k
C65 NET0107 NET0038 100n
DLED20 Net-_LED20-K_ +5V LED_D_G
R90 0 Net-_LED20-K_ 560
R59 NET0142 Net-_D6-A_ 10k
C7 Net-_D6-A_ 0 2.2u
C55 Net-_REG3-PVDD_ 0 2.2u
R26 NET0050 NET0007 10k
C57 NET0050 0 100u
C1 NET0050 0 47u
R63 0 Net-_LED11-K_ 240
DLED11 Net-_LED11-K_ +3.3V LED_D_G
C23 +5V 0 10u
C113 +3.3V 0 10u
C39 NET0031 0 10p
C19 Net-_C19-Pad1_ 0 10p
R74 NET0087 Net-_C19-Pad1_ 620
C92 +3V3 0 100n
C93 +3V3 0 100n
R94 +3V3 NET0048 4.7k
R70 +3V3 NET0029 4.7k
R9 +3V3 NET0088 4.7k
R89 +3V3 NET0076 4.7k
C106 +3V3 0 100n
C94 +3V3 0 100n
DLED16 Net-_LED16-K_ NET0022 LED_D_B
R47 0 Net-_LED16-K_ 100
R48 +3V3 NET0133 4.7k
R3 +3V3 NET0157 4.7k
C26 VREF+_FCC 0 100n
R54 VREF+_FCC VDDA_FCC 47
C32 VDDA_FCC 0 100n
R81 0 Net-_LED1-K_ 330
R88 0 Net-_LED10-K_ 330
DLED21 Net-_LED21-K_ NET0146 LED_D_B
R72 0 Net-_LED21-K_ 100
C11 NET0036 0 100n
R39 0 Net-_LED9-K_ 330
DLED5 Net-_LED5-K_ NET0152 LED_D_B
DLED9 Net-_LED9-K_ NET0098 LED_D_Y
R21 0 Net-_LED5-K_ 100
DLED1 Net-_LED1-K_ NET0136 LED_D_R
DLED10 Net-_LED10-K_ NET0049 LED_D_R
C17 +3V3 0 100n
C72 +3V3 0 100n
C108 +3V3 0 100n
C27 +3V3 0 100n
C64 +3V3 0 100n
C81 +3V3 0 100n
C16 +3V3 0 100n
C69 Net-_FCC2-PH0_ 0 2.2u
C44 unconnected-_C44-Pad1_ 0 2.2u
R49 Net-_SW3-C_ NET0026 10k
R31 NET0102 Net-_C24-Pad1_ 620
C24 Net-_C24-Pad1_ 0 10p
C25 NET0138 0 10p
R60 +3V3 NET0052 4.7k
R12 +3V3 NET0166 4.7k
R19 +3V3 NET0120 4.7k
R4 +3V3 NET0081 4.7k
DLED13 Net-_LED13-K_ NET0118 LED_D_Y
DLED8 Net-_LED8-K_ NET0044 LED_D_B
R68 0 Net-_LED13-K_ 330
R46 0 Net-_LED8-K_ 100
DLED19 Net-_LED19-K_ NET0168 LED_D_R
R93 0 Net-_LED19-K_ 330
DLED6 Net-_LED6-K_ NET0053 LED_D_R
R6 0 Net-_LED6-K_ 330
C43 Net-_NAVC2-PH1_ 0 2.2u
C20 Net-_NAVC2-PH0_ 0 2.2u
C78 +3V3 0 100n
C82 +3V3 0 100n
C71 VDDA_NAVC 0 100n
C12 +3V3 0 100n
C75 +3V3 0 100n
C111 +3V3 0 100n
C46 +3V3 0 100n
C68 +3V3 0 100n
C13 +3V3 0 100n
C2 +3V3 0 100n
R28 Net-_SW8-C_ NET0163 10k
C41 NET0148 0 100n
R29 Net-_SW1-C_ NET0176 10k
R18 NET0150 NET0130 10
R75 NET0154 NET0105 10
R80 NET0170 NET0062 10
R86 NET0011 NET0079 10
R91 NET0057 NET0124 10
R84 NET0037 NET0177 10
R43 NET0104 NET0027 10
R64 NET0078 NET0040 10
R30 NET0018 Net-_USB3-D-_ 22
R76 NET0164 Net-_USB3-ID_ 560
R85 NET0001 Net-_USB3-D+_ 22
R36 NET0055 Net-_USB1-D+_ 22
R67 NET0165 Net-_USB1-D-_ 22
R24 NET0153 Net-_USB1-ID_ 560
DLED18 Net-_LED18-K_ Net-_D5-A_ LED_D_G
R14 0 Net-_LED18-K_ 560
C112 0 Net-_D5-A_ 100n
R34 0 Net-_LED22-K_ 560
DLED22 Net-_LED22-K_ Net-_D7-A_ LED_D_G
C90 0 Net-_D7-A_ 100n
R65 NET0009 NET0029 0
R87 NET0058 NET0076 0
R82 NET0032 NET0024 10
R53 NET0063 NET0039 10
C62 0 unconnected-_C62-Pad2_ 100n
C53 0 unconnected-_C53-Pad2_ 100n
C87 +3.3V 0 100n
R69 +3.3V Net-_U7-_WP__IO2__ 10k
R5 +3.3V Net-_U7-_HOLD__IO3__ 10k
C54 0 +3.3V 100n
C30 +3.3V 0 100n
C95 +3.3V 0 100n
C86 +3.3V 0 100n
C97 +3.3V 0 1u
C89 +3.3V 0 1u
C70 +3.3V 0 100n
C102 +3.3V 0 100n
C42 Net-_U4-C1_ 0 220n
R20 +3.3V NET0125 10k
C98 +3.3V 0 10u
R42 Net-_L3-Pad1_ Net-_U6-VCC_RF_ 10
C38 Net-_ANT2-Pad1_ Net-_U6-RF_IN_ 22p
C35 Net-_ANT2-Pad1_ 0 10n
L3 Net-_L3-Pad1_ Net-_ANT2-Pad1_ 27n
C79 +3.3V 0 100n
C48 +3.3V 0 100n
C49 Net-_U8-VO-_ Net-_U8-VO+_ 1n
C10 +3.3V 0 100n
R66 +3.3V NET0069 10k

V_3_3V +3.3V 0 DC 3.3
V_3V3 +3V3 0 DC 3.3
V_5V +5V 0 DC 5.0

.control
tran 100u 10m
set filetype=ascii
write Hades_raw.raw all
.endc

.end
