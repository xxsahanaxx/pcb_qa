.title KiCad schematic

.model LED_D_G D (Is=1p Rs=10 N=1.7)
.model LED_D_B D (Is=1p Rs=10 N=1.7)
.model LED_D_Y D (Is=1p Rs=10 N=1.7)
.model LED_D_R D (Is=1p Rs=10 N=1.7)

R93 NET0101 VIN+ 0.01
C106 +3.3V 0 100n
C61 +5V NET0069 4.7n
L2 NET0009 +5V 15u
R40 +5V NET0069 6.8k
C77 +5V 0 47u
C29 +5V 0 100u
C63 NET0009 Net-_C63-Pad2_ 100n
R33 0 NET0069 1.3k
R83 Net-_C63-Pad2_ NET0069 19.6k
C51 NET0009 NET0058 100n
DLED2 Net-_LED2-K_ +5V LED_D_G
R86 0 Net-_LED2-K_ 560
R50 NET0043 Net-_D4-A_ 10k
C72 Net-_D4-A_ 0 2.2u
C26 Net-_REG2-PVDD_ 0 2.2u
R27 NET0101 NET0146 10k
C27 NET0101 0 100u
C30 NET0101 0 47u
R10 0 Net-_LED21-K_ 240
DLED21 Net-_LED21-K_ +3.3V LED_D_G
C87 +5V 0 10u
C39 +3.3V 0 10u
C113 NET0119 0 10p
C82 Net-_C82-Pad1_ 0 10p
R13 NET0081 Net-_C82-Pad1_ 620
C109 +3V3 0 100n
C66 +3V3 0 100n
R51 +3V3 NET0164 4.7k
R20 +3V3 NET0014 4.7k
R53 +3V3 NET0033 4.7k
R22 +3V3 NET0061 4.7k
C56 +3V3 0 100n
C86 +3V3 0 100n
DLED13 Net-_LED13-K_ NET0173 LED_D_B
R37 0 Net-_LED13-K_ 100
R90 +3V3 NET0079 4.7k
R4 +3V3 NET0064 4.7k
C40 VREF+_FCC 0 100n
R77 VREF+_FCC VDDA_FCC 47
C10 VDDA_FCC 0 100n
R17 0 Net-_LED22-K_ 330
R16 0 Net-_LED11-K_ 330
DLED8 Net-_LED8-K_ NET0021 LED_D_B
R74 0 Net-_LED8-K_ 100
C84 NET0065 0 100n
R18 0 Net-_LED19-K_ 330
DLED15 Net-_LED15-K_ NET0008 LED_D_B
DLED19 Net-_LED19-K_ NET0026 LED_D_Y
R79 0 Net-_LED15-K_ 100
DLED22 Net-_LED22-K_ NET0126 LED_D_R
DLED11 Net-_LED11-K_ NET0158 LED_D_R
C108 +3V3 0 100n
C58 +3V3 0 100n
C46 +3V3 0 100n
C107 +3V3 0 100n
C91 +3V3 0 100n
C65 +3V3 0 100n
C4 +3V3 0 100n
C95 Net-_FCC2-PH0_ 0 2.2u
C71 unconnected-_C71-Pad1_ 0 2.2u
R43 Net-_SW1-C_ NET0004 10k
R6 NET0030 Net-_C64-Pad1_ 620
C64 Net-_C64-Pad1_ 0 10p
C79 NET0142 0 10p
R3 +3V3 NET0105 4.7k
R21 +3V3 NET0171 4.7k
R64 +3V3 NET0140 4.7k
R52 +3V3 NET0104 4.7k
DLED17 Net-_LED17-K_ NET0125 LED_D_Y
DLED14 Net-_LED14-K_ NET0010 LED_D_B
R60 0 Net-_LED17-K_ 330
R28 0 Net-_LED14-K_ 100
R8 0 Net-_LED1-K_ 330
R72 0 Net-_LED3-K_ 330
DLED3 Net-_LED3-K_ NET0046 LED_D_R
DLED1 Net-_LED1-K_ NET0168 LED_D_R
C76 Net-_NAVC2-PH1_ 0 2.2u
C3 Net-_NAVC2-PH0_ 0 2.2u
C74 +3V3 0 100n
C28 +3V3 0 100n
C50 VDDA_NAVC 0 100n
C112 +3V3 0 100n
C75 +3V3 0 100n
C53 +3V3 0 100n
C88 +3V3 0 100n
C73 +3V3 0 100n
C31 +3V3 0 100n
C12 +3V3 0 100n
R5 Net-_SW2-C_ NET0002 10k
C47 NET0134 0 100n
R61 Net-_SW3-C_ NET0133 10k
R91 NET0099 NET0145 10
R76 NET0007 NET0025 10
R38 NET0093 NET0115 10
R92 NET0078 NET0020 10
R1 NET0131 NET0052 10
R66 NET0147 NET0077 10
R81 NET0097 NET0138 10
R46 NET0112 NET0166 10
R63 NET0041 Net-_USB2-D-_ 22
R70 NET0038 Net-_USB2-ID_ 560
R57 NET0011 Net-_USB2-D+_ 22
R32 NET0051 Net-_USB5-D+_ 22
R36 NET0152 Net-_USB5-D-_ 22
R71 NET0139 Net-_USB5-ID_ 560
C14 0 unconnected-_C14-Pad2_ 100n
C21 0 Net-_D6-A_ 100n
DLED7 Net-_LED7-K_ Net-_D6-A_ LED_D_G
R12 0 Net-_LED7-K_ 560
C13 0 unconnected-_C13-Pad2_ 100n
C103 0 Net-_D7-A_ 100n
DLED20 Net-_LED20-K_ Net-_D7-A_ LED_D_G
R49 0 Net-_LED20-K_ 560
R84 NET0175 NET0071 10
R11 NET0054 NET0062 10
R78 NET0092 NET0014 0
R89 NET0116 NET0061 0
C97 +3.3V 0 100n
R24 +3.3V Net-_U15-_WP__IO2__ 10k
R19 +3.3V Net-_U15-_HOLD__IO3__ 10k
C59 0 +3.3V 100n
C99 +3.3V 0 100n
C96 +3.3V 0 100n
C57 +3.3V 0 100n
C102 +3.3V 0 1u
C89 +3.3V 0 1u
C81 +3.3V 0 100n
C105 +3.3V 0 100n
C55 Net-_U5-C1_ 0 220n
R65 +3.3V NET0136 10k
C90 +3.3V 0 10u
R80 Net-_L3-Pad1_ Net-_U9-VCC_RF_ 10
C2 Net-_ANT2-Pad1_ Net-_U9-RF_IN_ 22p
C49 Net-_ANT2-Pad1_ 0 10n
L3 Net-_L3-Pad1_ Net-_ANT2-Pad1_ 27n
C93 +3.3V 0 100n
C8 +3.3V 0 100n
C34 Net-_U3-VO-_ Net-_U3-VO+_ 1n
C9 +3.3V 0 100n
R30 +3.3V NET0153 10k

V_3_3V +3.3V 0 DC 3.3
V_3V3 +3V3 0 DC 3.3
V_5V +5V 0 DC 5.0

.control
tran 100u 10m
set filetype=ascii
write Hades_raw.raw all
.endc

.end
