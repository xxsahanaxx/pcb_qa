.title KiCad schematic

.model LED_D_G D (Is=1p Rs=10 N=1.7)
.model LED_D_B D (Is=1p Rs=10 N=1.7)
.model LED_D_Y D (Is=1p Rs=10 N=1.7)
.model LED_D_R D (Is=1p Rs=10 N=1.7)

R34 NET0161 VIN+ 0.01
C47 +3.3V 0 100n
C29 +5V NET0102 4.7n
L2 NET0011 +5V 15u
R53 +5V NET0102 6.8k
C25 +5V 0 47u
C40 +5V 0 100u
C67 NET0011 Net-_C67-Pad2_ 100n
R16 0 NET0102 1.3k
R69 Net-_C67-Pad2_ NET0102 19.6k
C31 NET0011 NET0029 100n
DLED10 Net-_LED10-K_ +5V LED_D_G
R65 0 Net-_LED10-K_ 560
R22 NET0057 Net-_D2-A_ 10k
C90 Net-_D2-A_ 0 2.2u
C101 Net-_REG2-PVDD_ 0 2.2u
R62 NET0161 NET0141 10k
C8 NET0161 0 100u
C21 NET0161 0 47u
R27 0 Net-_LED6-K_ 240
DLED6 Net-_LED6-K_ +3.3V LED_D_G
C96 +5V 0 10u
C52 +3.3V 0 10u
C82 NET0084 0 10p
C28 Net-_C28-Pad1_ 0 10p
R30 NET0019 Net-_C28-Pad1_ 620
C34 +3V3 0 100n
C80 +3V3 0 100n
R70 +3V3 NET0056 4.7k
R19 +3V3 NET0082 4.7k
R24 +3V3 NET0143 4.7k
R36 +3V3 NET0145 4.7k
C74 +3V3 0 100n
C41 +3V3 0 100n
DLED16 Net-_LED16-K_ NET0041 LED_D_B
R94 0 Net-_LED16-K_ 100
R48 +3V3 NET0031 4.7k
R93 +3V3 NET0125 4.7k
C18 VREF+_FCC 0 100n
R33 VREF+_FCC VDDA_FCC 47
C60 VDDA_FCC 0 100n
R63 0 Net-_LED19-K_ 330
R18 0 Net-_LED8-K_ 330
DLED15 Net-_LED15-K_ NET0024 LED_D_B
R1 0 Net-_LED15-K_ 100
C51 NET0034 0 100n
R88 0 Net-_LED9-K_ 330
DLED5 Net-_LED5-K_ NET0106 LED_D_B
DLED9 Net-_LED9-K_ NET0130 LED_D_Y
R52 0 Net-_LED5-K_ 100
DLED19 Net-_LED19-K_ NET0164 LED_D_R
DLED8 Net-_LED8-K_ NET0022 LED_D_R
C88 +3V3 0 100n
C7 +3V3 0 100n
C6 +3V3 0 100n
C16 +3V3 0 100n
C38 +3V3 0 100n
C33 +3V3 0 100n
C85 +3V3 0 100n
C56 Net-_FCC2-PH0_ 0 2.2u
C76 unconnected-_C76-Pad1_ 0 2.2u
R37 Net-_SW5-C_ NET0028 10k
R82 NET0166 Net-_C70-Pad1_ 620
C70 Net-_C70-Pad1_ 0 10p
C87 NET0073 0 10p
R74 +3V3 NET0079 4.7k
R35 +3V3 NET0062 4.7k
R7 +3V3 NET0055 4.7k
R3 +3V3 NET0006 4.7k
DLED18 Net-_LED18-K_ NET0025 LED_D_Y
DLED2 Net-_LED2-K_ NET0014 LED_D_B
R66 0 Net-_LED18-K_ 330
R2 0 Net-_LED2-K_ 100
DLED7 Net-_LED7-K_ NET0099 LED_D_R
R25 0 Net-_LED7-K_ 330
DLED11 Net-_LED11-K_ NET0076 LED_D_R
R49 0 Net-_LED11-K_ 330
C45 Net-_NAVC2-PH1_ 0 2.2u
C79 Net-_NAVC2-PH0_ 0 2.2u
C20 +3V3 0 100n
C84 +3V3 0 100n
C73 VDDA_NAVC 0 100n
C77 +3V3 0 100n
C58 +3V3 0 100n
C107 +3V3 0 100n
C9 +3V3 0 100n
C3 +3V3 0 100n
C66 +3V3 0 100n
C36 +3V3 0 100n
R41 Net-_SW4-C_ NET0005 10k
C93 NET0157 0 100n
R91 Net-_SW6-C_ NET0044 10k
R45 NET0030 NET0155 10
R75 NET0146 NET0169 10
R43 NET0083 NET0109 10
R83 NET0091 NET0081 10
R46 NET0067 NET0065 10
R57 NET0066 NET0077 10
R89 NET0012 NET0111 10
R58 NET0174 NET0105 10
R84 NET0149 Net-_USB2-D-_ 22
R85 NET0137 Net-_USB2-ID_ 560
R78 NET0092 Net-_USB2-D+_ 22
R29 NET0135 Net-_USB1-D+_ 22
R14 NET0075 Net-_USB1-D-_ 22
R31 NET0007 Net-_USB1-ID_ 560
DLED20 Net-_LED20-K_ Net-_D6-A_ LED_D_G
R38 0 Net-_LED20-K_ 560
C24 0 Net-_D6-A_ 100n
R23 0 Net-_LED1-K_ 560
DLED1 Net-_LED1-K_ Net-_D3-A_ LED_D_G
C89 0 Net-_D3-A_ 100n
R6 NET0042 NET0082 0
R55 NET0140 NET0145 0
R71 NET0152 NET0052 10
R15 NET0069 NET0110 10
C111 0 unconnected-_C111-Pad2_ 100n
C13 0 unconnected-_C13-Pad2_ 100n
C14 +3.3V 0 100n
R28 +3.3V Net-_U8-_WP__IO2__ 10k
R76 +3.3V Net-_U8-_HOLD__IO3__ 10k
C5 0 +3.3V 100n
C113 +3.3V 0 100n
C10 +3.3V 0 100n
C32 +3.3V 0 100n
C105 +3.3V 0 1u
C49 +3.3V 0 1u
C75 +3.3V 0 100n
C2 +3.3V 0 100n
C54 Net-_U18-C1_ 0 220n
R40 +3.3V NET0068 10k
C106 +3.3V 0 10u
R5 Net-_L3-Pad1_ Net-_U7-VCC_RF_ 10
C94 Net-_ANT2-Pad1_ Net-_U7-RF_IN_ 22p
C12 Net-_ANT2-Pad1_ 0 10n
L3 Net-_L3-Pad1_ Net-_ANT2-Pad1_ 27n
C69 +3.3V 0 100n
C57 +3.3V 0 100n
C112 Net-_U13-VO-_ Net-_U13-VO+_ 1n
C48 +3.3V 0 100n
R9 +3.3V NET0123 10k

V_3_3V +3.3V 0 DC 3.3
V_3V3 +3V3 0 DC 3.3
V_5V +5V 0 DC 5.0

.control
tran 100u 10m
set filetype=ascii
write Hades_raw.raw all
.endc

.end
