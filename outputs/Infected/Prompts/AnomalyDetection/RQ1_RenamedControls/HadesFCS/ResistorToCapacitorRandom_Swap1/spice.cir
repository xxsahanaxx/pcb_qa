.title KiCad schematic

.model LED_D_G D (Is=1p Rs=10 N=1.7)
.model LED_D_B D (Is=1p Rs=10 N=1.7)
.model LED_D_Y D (Is=1p Rs=10 N=1.7)
.model LED_D_R D (Is=1p Rs=10 N=1.7)

R7 NET0092 VIN+ 0.01
C72 +3.3V 0 100n
C40 +5V NET0164 4.7n
L2 NET0160 +5V 15u
R90 +5V NET0164 6.8k
C5 +5V 0 47u
C88 +5V 0 100u
C56 NET0160 Net-_C56-Pad2_ 100n
R56 0 NET0164 1.3k
R15 Net-_C56-Pad2_ NET0164 19.6k
C17 NET0160 NET0051 100n
DLED7 Net-_LED7-K_ +5V LED_D_G
R18 0 Net-_LED7-K_ 560
R45 NET0011 Net-_D8-A_ 10k
C42 Net-_D8-A_ 0 2.2u
C90 Net-_REG2-PVDD_ 0 2.2u
R89 NET0092 NET0109 10k
C43 NET0092 0 100u
C12 NET0092 0 47u
R51 0 Net-_LED14-K_ 240
DLED14 Net-_LED14-K_ +3.3V LED_D_G
C60 +5V 0 10u
C64 +3.3V 0 10u
C13 NET0072 0 10p
C82 Net-_C82-Pad1_ 0 10p
R65 NET0003 Net-_C82-Pad1_ 620
C101 +3V3 0 100n
C80 +3V3 0 100n
R87 +3V3 NET0006 4.7k
R57 +3V3 NET0151 4.7k
R27 +3V3 NET0127 4.7k
R93 +3V3 NET0088 4.7k
C14 +3V3 0 100n
C49 +3V3 0 100n
DLED21 Net-_LED21-K_ NET0157 LED_D_B
R78 0 Net-_LED21-K_ 100
R1 +3V3 NET0085 4.7k
R10 +3V3 NET0113 4.7k
C6 VREF+_FCC 0 100n
R19 VREF+_FCC VDDA_FCC 47
C66 VDDA_FCC 0 100n
R73 0 Net-_LED8-K_ 330
R59 0 Net-_LED11-K_ 330
DLED5 Net-_LED5-K_ NET0135 LED_D_B
R77 0 Net-_LED5-K_ 100
C30 NET0140 0 100n
R67 0 Net-_LED15-K_ 330
DLED19 Net-_LED19-K_ NET0138 LED_D_B
DLED15 Net-_LED15-K_ NET0022 LED_D_Y
R81 0 Net-_LED19-K_ 100
DLED8 Net-_LED8-K_ NET0082 LED_D_R
DLED11 Net-_LED11-K_ NET0039 LED_D_R
C35 +3V3 0 100n
C22 +3V3 0 100n
C110 +3V3 0 100n
C9 +3V3 0 100n
C27 +3V3 0 100n
C37 +3V3 0 100n
C78 +3V3 0 100n
C38 Net-_FCC2-PH0_ 0 2.2u
C32 unconnected-_C32-Pad1_ 0 2.2u
R11 Net-_SW8-C_ NET0063 10k
R47 NET0136 Net-_C47-Pad1_ 620
C47 Net-_C47-Pad1_ 0 10p
C58 NET0084 0 10p
R91 +3V3 NET0091 4.7k
R50 +3V3 NET0010 4.7k
R83 +3V3 NET0071 4.7k
R75 +3V3 NET0066 4.7k
DLED17 Net-_LED17-K_ NET0031 LED_D_Y
DLED16 Net-_LED16-K_ NET0093 LED_D_B
R54 0 Net-_LED17-K_ 330
R88 0 Net-_LED16-K_ 100
DLED4 Net-_LED4-K_ NET0013 LED_D_R
R68 0 Net-_LED4-K_ 330
DLED6 Net-_LED6-K_ NET0033 LED_D_R
R53 0 Net-_LED6-K_ 330
C100 Net-_NAVC2-PH1_ 0 2.2u
C98 Net-_NAVC2-PH0_ 0 2.2u
C94 +3V3 0 100n
C39 +3V3 0 100n
C93 VDDA_NAVC 0 100n
C65 +3V3 0 100n
C86 +3V3 0 100n
C28 +3V3 0 100n
C73 +3V3 0 100n
C16 +3V3 0 100n
C107 +3V3 0 100n
C2 +3V3 0 100n
R25 Net-_SW2-C_ NET0001 10k
C44 NET0122 0 100n
R21 Net-_SW3-C_ NET0133 10k
R12 NET0027 NET0107 10
R60 NET0040 NET0018 10
R46 NET0168 NET0143 10
R33 NET0062 NET0137 10
R2 NET0090 NET0119 10
R58 NET0065 NET0014 10
R5 NET0021 NET0167 10
R71 NET0030 NET0141 10
R30 NET0110 Net-_USB4-D-_ 22
R44 NET0016 Net-_USB4-ID_ 560
R6 NET0017 Net-_USB4-D+_ 22
R92 NET0080 Net-_USB1-D+_ 22
R48 NET0177 Net-_USB1-D-_ 22
R43 NET0166 Net-_USB1-ID_ 560
DLED18 Net-_LED18-K_ Net-_D6-A_ LED_D_G
R35 0 Net-_LED18-K_ 560
C18 0 Net-_D6-A_ 100n
R4 0 Net-_LED12-K_ 560
DLED12 Net-_LED12-K_ Net-_D4-A_ LED_D_G
C57 0 Net-_D4-A_ 100n
R72 NET0097 NET0151 0
R62 NET0079 NET0088 0
R24 NET0165 NET0083 10
R20 NET0045 NET0123 10
C31 0 unconnected-_C31-Pad2_ 100n
C26 0 unconnected-_C26-Pad2_ 100n
C68 +3.3V 0 100n
R84 +3.3V Net-_U9-_WP__IO2__ 10k
R28 +3.3V Net-_U9-_HOLD__IO3__ 10k
C11 0 +3.3V 100n
C108 +3.3V 0 100n
C23 +3.3V 0 100n
C3 +3.3V 0 100n
C45 +3.3V 0 1u
C77 +3.3V 0 1u
C84 +3.3V 0 100n
C96 +3.3V 0 100n
C111 Net-_U19-C1_ 0 220n
R36 +3.3V NET0049 10k
C99 +3.3V 0 10u
R29 Net-_L1-Pad1_ Net-_U11-VCC_RF_ 10
C74 Net-_ANT2-Pad1_ Net-_U11-RF_IN_ 22p
C104 Net-_ANT2-Pad1_ 0 10n
L1 Net-_L1-Pad1_ Net-_ANT2-Pad1_ 27n
C63 +3.3V 0 100n
C8 +3.3V 0 100n
C4 Net-_U12-VO-_ Net-_U12-VO+_ 1n
C81 +3.3V 0 100n
R52 +3.3V NET0058 10k

V_3_3V +3.3V 0 DC 3.3
V_3V3 +3V3 0 DC 3.3
V_5V +5V 0 DC 5.0

.control
tran 100u 10m
set filetype=ascii
write Hades_raw.raw all
.endc

.end
