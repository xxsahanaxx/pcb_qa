.title KiCad schematic

.model LED_D_G D (Is=1p Rs=10 N=1.7)
.model LED_D_B D (Is=1p Rs=10 N=1.7)
.model LED_D_Y D (Is=1p Rs=10 N=1.7)
.model LED_D_R D (Is=1p Rs=10 N=1.7)

R41 NET0168 VIN+ 0.01
C3 +3.3V 0 100n
C66 +5V NET0051 4.7n
L2 NET0057 +5V 15u
R78 +5V NET0051 6.8k
C81 +5V 0 47u
C99 +5V 0 100u
C48 NET0057 Net-_C48-Pad2_ 100n
R55 0 NET0051 1.3k
R6 Net-_C48-Pad2_ NET0051 19.6k
C16 NET0057 NET0066 100n
DLED2 Net-_LED2-K_ +5V LED_D_G
R63 0 Net-_LED2-K_ 560
R21 NET0027 Net-_D5-A_ 10k
C72 Net-_D5-A_ 0 2.2u
C10 Net-_REG2-PVDD_ 0 2.2u
R53 NET0168 NET0035 10k
C104 NET0168 0 100u
C76 NET0168 0 47u
R62 0 Net-_LED21-K_ 240
DLED21 Net-_LED21-K_ +3.3V LED_D_G
C24 +5V 0 10u
C4 +3.3V 0 10u
C50 NET0025 0 10p
C42 Net-_C42-Pad1_ 0 10p
R60 NET0079 Net-_C42-Pad1_ 620
C64 +3V3 0 100n
C102 +3V3 0 100n
R45 +3V3 NET0088 4.7k
R83 +3V3 NET0161 4.7k
R67 +3V3 NET0170 4.7k
R52 +3V3 NET0052 4.7k
C55 +3V3 0 100n
C79 +3V3 0 100n
DLED6 Net-_LED6-K_ NET0117 LED_D_B
R91 0 Net-_LED6-K_ 100
R94 +3V3 NET0101 4.7k
R85 +3V3 NET0125 4.7k
C56 VREF+_FCC 0 100n
R74 VREF+_FCC VDDA_FCC 47
C62 VDDA_FCC 0 100n
R25 0 Net-_LED15-K_ 330
R4 0 Net-_LED17-K_ 330
DLED11 Net-_LED11-K_ NET0108 LED_D_B
R37 0 Net-_LED11-K_ 100
C93 NET0174 0 100n
R27 0 Net-_LED13-K_ 330
DLED8 Net-_LED8-K_ NET0031 LED_D_B
DLED13 Net-_LED13-K_ NET0015 LED_D_Y
R65 0 Net-_LED8-K_ 100
DLED15 Net-_LED15-K_ NET0020 LED_D_R
DLED17 Net-_LED17-K_ NET0087 LED_D_R
C1 +3V3 0 100n
C20 +3V3 0 100n
C30 +3V3 0 100n
C61 +3V3 0 100n
C113 +3V3 0 100n
C5 +3V3 0 100n
C36 +3V3 0 100n
C34 Net-_FCC2-PH0_ 0 2.2u
C60 unconnected-_C60-Pad1_ 0 2.2u
R34 Net-_SW8-C_ NET0154 10k
R86 NET0037 Net-_C101-Pad1_ 620
C101 Net-_C101-Pad1_ 0 10p
C84 NET0009 0 10p
R92 +3V3 NET0038 4.7k
R26 +3V3 NET0132 4.7k
R73 +3V3 NET0010 4.7k
R30 +3V3 NET0135 4.7k
DLED19 Net-_LED19-K_ NET0083 LED_D_Y
DLED4 Net-_LED4-K_ NET0105 LED_D_B
R32 0 Net-_LED19-K_ 330
R19 0 Net-_LED4-K_ 100
DLED3 Net-_LED3-K_ NET0144 LED_D_R
R31 0 Net-_LED3-K_ 330
DLED20 Net-_LED20-K_ NET0147 LED_D_R
R1 0 Net-_LED20-K_ 330
C14 Net-_NAVC2-PH1_ 0 2.2u
C54 Net-_NAVC2-PH0_ 0 2.2u
C69 +3V3 0 100n
C96 +3V3 0 100n
C25 VDDA_NAVC 0 100n
C32 +3V3 0 100n
C6 +3V3 0 100n
C98 +3V3 0 100n
C107 +3V3 0 100n
C45 +3V3 0 100n
C63 +3V3 0 100n
C11 +3V3 0 100n
R54 Net-_SW2-C_ NET0167 10k
C2 NET0046 0 100n
R35 Net-_SW6-C_ NET0123 10k
R8 NET0060 NET0075 10
R58 NET0116 NET0089 10
R71 NET0078 NET0173 10
R70 NET0012 NET0042 10
R18 NET0106 NET0062 10
R23 NET0127 NET0030 10
R29 NET0145 NET0023 10
R2 NET0048 NET0099 10
R39 NET0112 Net-_USB3-D-_ 22
R81 NET0055 Net-_USB3-ID_ 560
R36 NET0169 Net-_USB3-D+_ 22
R11 NET0096 Net-_USB6-D+_ 22
R89 NET0092 Net-_USB6-D-_ 22
R77 NET0097 Net-_USB6-ID_ 560
C90 0 unconnected-_C90-Pad2_ 100n
C51 0 Net-_D1-A_ 100n
DLED1 Net-_LED1-K_ Net-_D1-A_ LED_D_G
R56 0 Net-_LED1-K_ 560
C39 0 unconnected-_C39-Pad2_ 100n
C95 0 Net-_D4-A_ 100n
DLED5 Net-_LED5-K_ Net-_D4-A_ LED_D_G
R68 0 Net-_LED5-K_ 560
R66 NET0069 NET0018 10
R69 NET0118 NET0126 10
R20 NET0080 NET0161 0
R88 NET0006 NET0052 0
C83 +3.3V 0 100n
R49 +3.3V Net-_U19-_WP__IO2__ 10k
R72 +3.3V Net-_U19-_HOLD__IO3__ 10k
C89 0 +3.3V 100n
C38 +3.3V 0 100n
C46 +3.3V 0 100n
C52 +3.3V 0 100n
C40 +3.3V 0 1u
C12 +3.3V 0 1u
C59 +3.3V 0 100n
C73 +3.3V 0 100n
C8 Net-_U17-C1_ 0 220n
R90 +3.3V NET0148 10k
C103 +3.3V 0 10u
R13 Net-_L3-Pad1_ Net-_U11-VCC_RF_ 10
C22 Net-_ANT2-Pad1_ Net-_U11-RF_IN_ 22p
C80 Net-_ANT2-Pad1_ 0 10n
L3 Net-_L3-Pad1_ Net-_ANT2-Pad1_ 27n
C28 +3.3V 0 100n
C91 +3.3V 0 100n
C33 Net-_U9-VO-_ Net-_U9-VO+_ 1n
C47 +3.3V 0 100n
R7 +3.3V NET0047 10k

V_3_3V +3.3V 0 DC 3.3
V_3V3 +3V3 0 DC 3.3
V_5V +5V 0 DC 5.0

.control
tran 100u 10m
set filetype=ascii
write Hades_raw.raw all
.endc

.end
