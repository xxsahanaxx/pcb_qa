.title KiCad schematic

.model LED_D_G D (Is=1p Rs=10 N=1.7)
.model LED_D_B D (Is=1p Rs=10 N=1.7)
.model LED_D_Y D (Is=1p Rs=10 N=1.7)
.model LED_D_R D (Is=1p Rs=10 N=1.7)

R71 NET0144 VIN+ 0.01
C39 +3.3V 0 100n
C20 +5V NET0107 4.7n
L2 NET0050 +5V 15u
R48 +5V NET0107 6.8k
C51 +5V 0 47u
C42 +5V 0 100u
C31 NET0050 Net-_C31-Pad2_ 100n
R85 0 NET0107 1.3k
R42 Net-_C31-Pad2_ NET0107 19.6k
C11 NET0050 NET0090 100n
DLED6 Net-_LED6-K_ +5V LED_D_G
R64 0 Net-_LED6-K_ 560
R73 NET0080 Net-_D5-A_ 10k
C96 Net-_D5-A_ 0 2.2u
C93 Net-_REG3-PVDD_ 0 2.2u
R58 NET0144 NET0046 10k
C70 NET0144 0 100u
C54 NET0144 0 47u
R90 0 Net-_LED21-K_ 240
DLED21 Net-_LED21-K_ +3.3V LED_D_G
C94 +5V 0 10u
C71 +3.3V 0 10u
C48 NET0148 0 10p
C27 Net-_C27-Pad1_ 0 10p
R47 NET0013 Net-_C27-Pad1_ 620
C65 +3V3 0 100n
C64 +3V3 0 100n
R16 +3V3 NET0163 4.7k
R80 +3V3 NET0113 4.7k
R30 +3V3 NET0058 4.7k
R62 +3V3 NET0037 4.7k
C37 +3V3 0 100n
C3 +3V3 0 100n
DLED15 Net-_LED15-K_ NET0108 LED_D_B
R28 0 Net-_LED15-K_ 100
R74 +3V3 NET0082 4.7k
R1 +3V3 NET0175 4.7k
C92 VREF+_FCC 0 100n
R84 VREF+_FCC VDDA_FCC 47
C12 VDDA_FCC 0 100n
R29 0 Net-_LED9-K_ 330
R66 0 Net-_LED2-K_ 330
DLED13 Net-_LED13-K_ NET0019 LED_D_B
R6 0 Net-_LED13-K_ 100
C13 NET0130 0 100n
R36 0 Net-_LED17-K_ 330
DLED22 Net-_LED22-K_ NET0008 LED_D_B
DLED17 Net-_LED17-K_ NET0063 LED_D_Y
R60 0 Net-_LED22-K_ 100
DLED9 Net-_LED9-K_ NET0073 LED_D_R
DLED2 Net-_LED2-K_ NET0117 LED_D_R
C62 +3V3 0 100n
C2 +3V3 0 100n
C90 +3V3 0 100n
C8 +3V3 0 100n
C21 +3V3 0 100n
C112 +3V3 0 100n
C79 +3V3 0 100n
C69 Net-_FCC2-PH0_ 0 2.2u
C41 unconnected-_C41-Pad1_ 0 2.2u
R91 Net-_SW8-C_ NET0005 10k
R2 NET0100 Net-_C104-Pad1_ 620
C104 Net-_C104-Pad1_ 0 10p
C82 NET0110 0 10p
R88 +3V3 NET0038 4.7k
R7 +3V3 NET0149 4.7k
R43 +3V3 NET0170 4.7k
R78 +3V3 NET0083 4.7k
DLED14 Net-_LED14-K_ NET0168 LED_D_Y
DLED5 Net-_LED5-K_ NET0051 LED_D_B
R27 0 Net-_LED14-K_ 330
R87 0 Net-_LED5-K_ 100
DLED7 Net-_LED7-K_ NET0039 LED_D_R
R92 0 Net-_LED7-K_ 330
DLED8 Net-_LED8-K_ NET0091 LED_D_R
R79 0 Net-_LED8-K_ 330
C88 Net-_NAVC2-PH1_ 0 2.2u
C78 Net-_NAVC2-PH0_ 0 2.2u
C100 +3V3 0 100n
C28 +3V3 0 100n
C84 VDDA_NAVC 0 100n
C81 +3V3 0 100n
C19 +3V3 0 100n
C111 +3V3 0 100n
C35 +3V3 0 100n
C36 +3V3 0 100n
C109 +3V3 0 100n
C16 +3V3 0 100n
R81 Net-_SW7-C_ NET0121 10k
C108 NET0156 0 100n
R70 Net-_SW5-C_ NET0071 10k
R50 NET0036 NET0006 10
R18 NET0096 NET0106 10
R21 NET0079 NET0137 10
R89 NET0141 NET0032 10
R5 NET0173 NET0068 10
R34 NET0147 NET0084 10
R22 NET0139 NET0074 10
R37 NET0150 NET0126 10
R56 NET0146 Net-_USB3-D-_ 22
R65 NET0145 Net-_USB3-ID_ 560
R93 NET0048 Net-_USB3-D+_ 22
R63 NET0116 Net-_USB4-D+_ 22
R8 NET0169 Net-_USB4-D-_ 22
R39 NET0122 Net-_USB4-ID_ 560
C46 0 unconnected-_C46-Pad2_ 100n
C49 0 Net-_D2-A_ 100n
DLED1 Net-_LED1-K_ Net-_D2-A_ LED_D_G
R35 0 Net-_LED1-K_ 560
C66 0 unconnected-_C66-Pad2_ 100n
C9 0 Net-_D4-A_ 100n
DLED12 Net-_LED12-K_ Net-_D4-A_ LED_D_G
R45 0 Net-_LED12-K_ 560
R33 NET0076 NET0059 10
R11 NET0004 NET0030 10
R10 NET0040 NET0113 0
R32 NET0111 NET0037 0
C52 +3.3V 0 100n
R17 +3.3V Net-_U7-_WP__IO2__ 10k
R82 +3.3V Net-_U7-_HOLD__IO3__ 10k
C59 0 +3.3V 100n
C67 +3.3V 0 100n
C80 +3.3V 0 100n
C10 +3.3V 0 100n
C89 +3.3V 0 1u
C107 +3.3V 0 1u
C98 +3.3V 0 100n
C33 +3.3V 0 100n
C76 Net-_U10-C1_ 0 220n
R23 +3.3V NET0081 10k
C77 +3.3V 0 10u
R76 Net-_L3-Pad1_ Net-_U13-VCC_RF_ 10
C55 Net-_ANT2-Pad1_ Net-_U13-RF_IN_ 22p
C97 Net-_ANT2-Pad1_ 0 10n
L3 Net-_L3-Pad1_ Net-_ANT2-Pad1_ 27n
C5 +3.3V 0 100n
C56 +3.3V 0 100n
C34 Net-_U17-VO-_ Net-_U17-VO+_ 1n
C29 +3.3V 0 100n
R14 +3.3V NET0085 10k

V_3_3V +3.3V 0 DC 3.3
V_3V3 +3V3 0 DC 3.3
V_5V +5V 0 DC 5.0

.control
tran 100u 10m
set filetype=ascii
write Hades_raw.raw all
.endc

.end
