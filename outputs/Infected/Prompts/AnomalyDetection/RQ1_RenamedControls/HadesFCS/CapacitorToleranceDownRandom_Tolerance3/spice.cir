.title KiCad schematic

.model LED_D_G D (Is=1p Rs=10 N=1.7)
.model LED_D_B D (Is=1p Rs=10 N=1.7)
.model LED_D_Y D (Is=1p Rs=10 N=1.7)
.model LED_D_R D (Is=1p Rs=10 N=1.7)

R26 NET0074 VIN+ 0.01
C113 +3.3V 0 100n
C97 +5V NET0112 4.7n
L2 NET0061 +5V 15u
R58 +5V NET0112 6.8k
C20 +5V 0 47u
C79 +5V 0 100u
C100 NET0061 Net-_C100-Pad2_ 100n
R51 0 NET0112 1.3k
R33 Net-_C100-Pad2_ NET0112 19.6k
C23 NET0061 NET0152 100n
DLED5 Net-_LED5-K_ +5V LED_D_G
R49 0 Net-_LED5-K_ 560
R5 NET0128 Net-_D7-A_ 10k
C30 Net-_D7-A_ 0 2.2u
C39 NET0074 0 100u
C111 NET0074 0 47u
R31 NET0074 NET0064 10k
C60 Net-_REG2-PVDD_ 0 2.2u
R2 0 Net-_LED12-K_ 240
DLED12 Net-_LED12-K_ +3.3V LED_D_G
C84 +5V 0 10u
C33 +3.3V 0 10u
C16 NET0130 0 10p
C29 Net-_C29-Pad1_ 0 10p
R66 NET0039 Net-_C29-Pad1_ 620
C24 +3V3 0 100n
C65 +3V3 0 100n
R7 +3V3 NET0027 4.7k
R64 +3V3 NET0121 4.7k
R94 +3V3 NET0023 4.7k
R6 +3V3 NET0080 4.7k
C106 +3V3 0 100n
C87 +3V3 0 100n
DLED2 Net-_LED2-K_ NET0047 LED_D_B
R30 0 Net-_LED2-K_ 100
R56 +3V3 NET0133 4.7k
R9 +3V3 NET0066 4.7k
C105 VREF+_FCC 0 100n
R11 VREF+_FCC VDDA_FCC 47
C32 VDDA_FCC 0 100n
R87 0 Net-_LED10-K_ 330
R23 0 Net-_LED4-K_ 330
DLED9 Net-_LED9-K_ NET0053 LED_D_B
R24 0 Net-_LED9-K_ 100
C86 NET0134 0 100n
R57 0 Net-_LED8-K_ 330
DLED14 Net-_LED14-K_ NET0107 LED_D_B
DLED8 Net-_LED8-K_ NET0174 LED_D_Y
R76 0 Net-_LED14-K_ 100
DLED10 Net-_LED10-K_ NET0018 LED_D_R
DLED4 Net-_LED4-K_ NET0119 LED_D_R
C38 +3V3 0 100n
C8 +3V3 0 100n
C57 +3V3 0 100n
C27 +3V3 0 100n
C22 +3V3 0 100n
C75 +3V3 0 100n
C66 +3V3 0 100n
C43 Net-_FCC2-PH0_ 0 2.2u
C80 unconnected-_C80-Pad1_ 0 2.2u
R54 Net-_SW7-C_ NET0148 10k
R80 NET0055 Net-_C83-Pad1_ 620
C83 Net-_C83-Pad1_ 0 10p
C1 NET0024 0 10p
R40 +3V3 NET0150 4.7k
R61 +3V3 NET0015 4.7k
R90 +3V3 NET0090 4.7k
R69 +3V3 NET0040 4.7k
DLED13 Net-_LED13-K_ NET0120 LED_D_Y
DLED7 Net-_LED7-K_ NET0038 LED_D_B
R73 0 Net-_LED13-K_ 330
R16 0 Net-_LED7-K_ 100
DLED21 Net-_LED21-K_ NET0153 LED_D_R
R14 0 Net-_LED21-K_ 330
DLED16 Net-_LED16-K_ NET0060 LED_D_R
R46 0 Net-_LED16-K_ 330
C107 Net-_NAVC2-PH1_ 0 2.2u
C93 Net-_NAVC2-PH0_ 0 2.2u
C92 +3V3 0 100n
C54 +3V3 0 100n
C98 VDDA_NAVC 0 100n
C81 +3V3 0 100n
C46 +3V3 0 100n
C88 +3V3 0 100n
C82 +3V3 0 100n
C73 +3V3 0 100n
C71 +3V3 0 100n
C15 +3V3 0 100n
R4 Net-_SW1-C_ NET0073 10k
C89 NET0172 0 100n
R88 Net-_SW2-C_ NET0063 10k
R92 NET0160 NET0058 10
R19 NET0036 NET0091 10
R28 NET0028 NET0167 10
R41 NET0135 NET0059 10
R43 NET0142 NET0099 10
R38 NET0021 NET0022 10
R48 NET0108 NET0070 10
R17 NET0034 NET0163 10
R18 NET0037 Net-_USB4-D-_ 22
R74 NET0155 Net-_USB4-ID_ 560
R71 NET0144 Net-_USB4-D+_ 22
R34 NET0149 Net-_USB6-D+_ 22
R82 NET0052 Net-_USB6-D-_ 22
R22 NET0009 Net-_USB6-ID_ 560
C55 0 unconnected-_C55-Pad2_ 100n
C56 0 Net-_D8-A_ 100n
DLED6 Net-_LED6-K_ Net-_D8-A_ LED_D_G
R78 0 Net-_LED6-K_ 560
C91 0 unconnected-_C91-Pad2_ 100n
C68 0 Net-_D3-A_ 100n
DLED15 Net-_LED15-K_ Net-_D3-A_ LED_D_G
R20 0 Net-_LED15-K_ 560
R79 NET0123 NET0093 10
R77 NET0127 NET0131 10
R12 NET0088 NET0121 0
R53 NET0157 NET0080 0
C48 +3.3V 0 100n
R60 +3.3V Net-_U16-_WP__IO2__ 10k
R44 +3.3V Net-_U16-_HOLD__IO3__ 10k
C25 0 +3.3V 100n
C21 +3.3V 0 100n
C69 +3.3V 0 100n
C104 +3.3V 0 100n
C36 +3.3V 0 1u
C28 +3.3V 0 1u
C67 +3.3V 0 100n
C112 +3.3V 0 100n
C70 Net-_U18-C1_ 0 220n
R63 +3.3V NET0046 10k
C52 +3.3V 0 10u
R32 Net-_L3-Pad1_ Net-_U17-VCC_RF_ 10
C109 Net-_ANT2-Pad1_ Net-_U17-RF_IN_ 22p
C42 Net-_ANT2-Pad1_ 0 10n
L3 Net-_L3-Pad1_ Net-_ANT2-Pad1_ 27n
C58 +3.3V 0 100n
C94 +3.3V 0 100n
C85 Net-_U14-VO-_ Net-_U14-VO+_ 1n
C96 +3.3V 0 100n
R35 +3.3V NET0078 10k

V_3_3V +3.3V 0 DC 3.3
V_3V3 +3V3 0 DC 3.3
V_5V +5V 0 DC 5.0

.control
tran 100u 10m
set filetype=ascii
write Hades_raw.raw all
.endc

.end
