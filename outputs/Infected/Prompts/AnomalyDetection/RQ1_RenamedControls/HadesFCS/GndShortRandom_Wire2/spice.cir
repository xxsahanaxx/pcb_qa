.title KiCad schematic

.model LED_D_G D (Is=1p Rs=10 N=1.7)
.model LED_D_B D (Is=1p Rs=10 N=1.7)
.model LED_D_Y D (Is=1p Rs=10 N=1.7)
.model LED_D_R D (Is=1p Rs=10 N=1.7)

R56 NET0147 VIN+ 0.01
C26 +3.3V 0 100n
C31 +5V NET0107 4.7n
L2 NET0033 +5V 15u
R53 +5V NET0107 6.8k
C56 +5V 0 47u
C88 +5V 0 100u
C68 NET0033 Net-_C68-Pad2_ 100n
R12 0 NET0107 1.3k
R60 Net-_C68-Pad2_ NET0107 19.6k
C33 NET0033 NET0038 100n
DLED4 Net-_LED4-K_ +5V LED_D_G
R94 0 Net-_LED4-K_ 560
R68 NET0051 Net-_D7-A_ 10k
C76 Net-_D7-A_ 0 2.2u
C63 Net-_REG3-PVDD_ 0 2.2u
R50 NET0147 NET0115 10k
C69 NET0147 0 100u
C66 NET0147 0 47u
R22 0 Net-_LED6-K_ 240
DLED6 Net-_LED6-K_ +3.3V LED_D_G
C6 +5V 0 10u
C103 +3.3V 0 10u
C83 NET0049 0 10p
C112 Net-_C112-Pad1_ 0 10p
R35 NET0093 Net-_C112-Pad1_ 620
C13 +3V3 0 100n
R75 +3V3 NET0018 4.7k
R74 +3V3 NET0072 4.7k
R1 +3V3 NET0062 4.7k
C104 +3V3 0 100n
C32 +3V3 0 100n
C23 +3V3 0 100n
R43 +3V3 NET0150 4.7k
R26 +3V3 NET0006 4.7k
R33 +3V3 NET0050 4.7k
C57 +3V3 0 100n
C107 +3V3 0 100n
DLED1 Net-_LED1-K_ NET0056 LED_D_B
R37 0 Net-_LED1-K_ 100
C109 VREF+_FCC 0 100n
R66 VREF+_FCC VDDA_FCC 47
C50 VDDA_FCC 0 100n
R72 0 Net-_LED8-K_ 330
R31 0 Net-_LED13-K_ 330
DLED21 Net-_LED21-K_ NET0036 LED_D_B
R20 0 Net-_LED21-K_ 100
C41 NET0145 0 100n
R79 0 Net-_LED17-K_ 330
DLED12 Net-_LED12-K_ NET0113 LED_D_B
DLED17 Net-_LED17-K_ NET0064 LED_D_Y
R10 0 Net-_LED12-K_ 100
DLED8 Net-_LED8-K_ NET0013 LED_D_R
DLED13 Net-_LED13-K_ NET0127 LED_D_R
C54 +3V3 0 100n
C46 +3V3 0 100n
C71 +3V3 0 100n
C106 +3V3 0 100n
C16 +3V3 0 100n
C59 Net-_FCC2-PH0_ 0 2.2u
C67 unconnected-_C67-Pad1_ 0 2.2u
R49 Net-_SW3-C_ NET0095 10k
R39 NET0008 Net-_C64-Pad1_ 620
C64 Net-_C64-Pad1_ 0 10p
C15 NET0080 0 10p
R93 +3V3 NET0084 4.7k
R78 +3V3 NET0124 4.7k
R13 +3V3 NET0017 4.7k
R81 +3V3 NET0066 4.7k
DLED3 Net-_LED3-K_ NET0120 LED_D_Y
DLED19 Net-_LED19-K_ NET0169 LED_D_B
R70 0 Net-_LED3-K_ 330
R16 0 Net-_LED19-K_ 100
DLED22 Net-_LED22-K_ NET0122 LED_D_R
R28 0 Net-_LED22-K_ 330
DLED11 Net-_LED11-K_ NET0137 LED_D_R
R65 0 Net-_LED11-K_ 330
C10 Net-_NAVC2-PH1_ 0 2.2u
C85 Net-_NAVC2-PH0_ 0 2.2u
C111 +3V3 0 100n
C96 +3V3 0 100n
C12 VDDA_NAVC 0 100n
C1 +3V3 0 100n
C53 +3V3 0 100n
C49 +3V3 0 100n
C29 +3V3 0 100n
C105 +3V3 0 100n
C89 +3V3 0 100n
C40 +3V3 0 100n
R69 Net-_SW8-C_ NET0060 10k
C52 NET0133 0 100n
R76 Net-_SW2-C_ NET0094 10k
R51 NET0110 NET0065 10
R90 NET0048 NET0098 10
R34 NET0163 NET0075 10
R63 NET0002 NET0029 10
R36 NET0170 NET0031 10
R58 NET0121 NET0052 10
R29 NET0144 NET0082 10
R52 NET0159 NET0055 10
R27 NET0035 Net-_USB4-D-_ 22
R4 NET0007 Net-_USB4-ID_ 560
R64 NET0138 Net-_USB4-D+_ 22
R67 NET0027 Net-_USB6-D+_ 22
R9 NET0067 Net-_USB6-D-_ 22
R17 NET0139 Net-_USB6-ID_ 560
DLED20 Net-_LED20-K_ Net-_D8-A_ LED_D_G
R41 0 Net-_LED20-K_ 560
C7 0 Net-_D8-A_ 100n
R6 0 Net-_LED9-K_ 560
DLED9 Net-_LED9-K_ Net-_D6-A_ LED_D_G
C99 0 Net-_D6-A_ 100n
R77 NET0102 NET0006 0
R7 NET0068 NET0050 0
R14 NET0086 NET0171 10
R91 NET0173 NET0046 10
C75 0 unconnected-_C75-Pad2_ 100n
C101 0 unconnected-_C101-Pad2_ 100n
C5 +3.3V 0 100n
R88 +3.3V Net-_U1-_WP__IO2__ 10k
R18 +3.3V Net-_U1-_HOLD__IO3__ 10k
C90 0 +3.3V 100n
C95 +3.3V 0 100n
C36 +3.3V 0 100n
C80 +3.3V 0 100n
C102 +3.3V 0 1u
C79 +3.3V 0 1u
C2 +3.3V 0 100n
C108 +3.3V 0 100n
C25 Net-_U18-C1_ 0 220n
R2 +3.3V NET0153 10k
C18 +3.3V 0 10u
R19 Net-_L3-Pad1_ Net-_U4-VCC_RF_ 10
C19 Net-_ANT2-Pad1_ Net-_U4-RF_IN_ 22p
C78 Net-_ANT2-Pad1_ 0 10n
L3 Net-_L3-Pad1_ Net-_ANT2-Pad1_ 27n
C39 +3.3V 0 100n
C27 +3.3V 0 100n
C93 Net-_U17-VO-_ Net-_U17-VO+_ 1n
C9 +3.3V 0 100n
R45 +3.3V NET0142 10k

V_3_3V +3.3V 0 DC 3.3
V_3V3 +3V3 0 DC 3.3
V_5V +5V 0 DC 5.0

.control
tran 100u 10m
set filetype=ascii
write Hades_raw.raw all
.endc

.end
