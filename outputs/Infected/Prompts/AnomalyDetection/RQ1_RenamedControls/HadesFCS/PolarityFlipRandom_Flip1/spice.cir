.title KiCad schematic

.model LED_D_G D (Is=1p Rs=10 N=1.7)
.model LED_D_B D (Is=1p Rs=10 N=1.7)
.model LED_D_Y D (Is=1p Rs=10 N=1.7)
.model LED_D_R D (Is=1p Rs=10 N=1.7)

R20 NET0158 VIN+ 0.01
C27 +3.3V 0 100n
C79 +5V NET0011 4.7n
L2 NET0027 +5V 15u
R36 +5V NET0011 6.8k
C64 +5V 0 47u
C11 +5V 0 100u
C97 NET0027 Net-_C97-Pad2_ 100n
R85 0 NET0011 1.3k
R18 Net-_C97-Pad2_ NET0011 19.6k
C68 NET0027 NET0163 100n
DLED7 Net-_LED7-K_ +5V LED_D_G
R54 0 Net-_LED7-K_ 560
R77 NET0123 Net-_D4-A_ 10k
C74 Net-_D4-A_ 0 2.2u
C31 Net-_REG2-PVDD_ 0 2.2u
R42 NET0158 NET0079 10k
C26 NET0158 0 100u
C54 NET0158 0 47u
R65 0 Net-_LED19-K_ 240
DLED19 Net-_LED19-K_ +3.3V LED_D_G
C49 +5V 0 10u
C99 +3.3V 0 10u
C22 NET0052 0 10p
C96 Net-_C96-Pad1_ 0 10p
R72 NET0159 Net-_C96-Pad1_ 620
C9 +3V3 0 100n
C73 +3V3 0 100n
R59 +3V3 NET0142 4.7k
R49 +3V3 NET0131 4.7k
R75 +3V3 NET0039 4.7k
R50 +3V3 NET0014 4.7k
C66 +3V3 0 100n
C89 +3V3 0 100n
DLED11 Net-_LED11-K_ NET0106 LED_D_B
R83 0 Net-_LED11-K_ 100
R8 +3V3 NET0037 4.7k
R32 +3V3 NET0124 4.7k
C40 VREF+_FCC 0 100n
R43 VREF+_FCC VDDA_FCC 47
C33 VDDA_FCC 0 100n
R58 0 Net-_LED12-K_ 330
R6 0 Net-_LED10-K_ 330
DLED17 Net-_LED17-K_ NET0134 LED_D_B
R89 0 Net-_LED17-K_ 100
C42 NET0075 0 100n
R93 0 Net-_LED20-K_ 330
DLED8 Net-_LED8-K_ NET0099 LED_D_B
DLED20 Net-_LED20-K_ NET0055 LED_D_Y
R87 0 Net-_LED8-K_ 100
DLED12 Net-_LED12-K_ NET0096 LED_D_R
DLED10 Net-_LED10-K_ NET0057 LED_D_R
C47 +3V3 0 100n
C55 +3V3 0 100n
C12 +3V3 0 100n
C80 +3V3 0 100n
C88 +3V3 0 100n
C104 +3V3 0 100n
C50 +3V3 0 100n
C107 Net-_FCC2-PH0_ 0 2.2u
C57 unconnected-_C57-Pad1_ 0 2.2u
R23 Net-_SW3-C_ NET0035 10k
R61 NET0102 Net-_C102-Pad1_ 620
C102 Net-_C102-Pad1_ 0 10p
C15 NET0122 0 10p
R41 +3V3 NET0118 4.7k
R29 +3V3 NET0127 4.7k
R17 +3V3 NET0024 4.7k
R80 +3V3 NET0033 4.7k
DLED22 Net-_LED22-K_ NET0042 LED_D_Y
DLED3 Net-_LED3-K_ NET0056 LED_D_B
R24 0 Net-_LED22-K_ 330
R56 0 Net-_LED3-K_ 100
DLED15 Net-_LED15-K_ NET0111 LED_D_R
R91 0 Net-_LED15-K_ 330
DLED1 Net-_LED1-K_ NET0176 LED_D_R
R7 0 Net-_LED1-K_ 330
C101 Net-_NAVC2-PH1_ 0 2.2u
C24 Net-_NAVC2-PH0_ 0 2.2u
C77 +3V3 0 100n
C46 +3V3 0 100n
C6 VDDA_NAVC 0 100n
C35 +3V3 0 100n
C43 +3V3 0 100n
C90 +3V3 0 100n
C52 +3V3 0 100n
C5 +3V3 0 100n
C2 +3V3 0 100n
C4 +3V3 0 100n
R71 Net-_SW5-C_ NET0136 10k
C63 NET0094 0 100n
R51 Net-_SW8-C_ NET0151 10k
R63 NET0047 NET0141 10
R34 NET0166 NET0108 10
R48 NET0128 NET0028 10
R84 NET0172 NET0061 10
R3 NET0007 NET0023 10
R4 NET0157 NET0046 10
R86 NET0162 NET0156 10
R26 NET0030 NET0002 10
R40 NET0109 Net-_USB3-D-_ 22
R82 NET0072 Net-_USB3-ID_ 560
R9 NET0139 Net-_USB3-D+_ 22
R33 NET0107 Net-_USB4-D+_ 22
R37 NET0130 Net-_USB4-D-_ 22
R53 NET0088 Net-_USB4-ID_ 560
DLED21 Net-_LED21-K_ Net-_D2-A_ LED_D_G
R64 0 Net-_LED21-K_ 560
C34 0 Net-_D2-A_ 100n
R68 0 Net-_LED9-K_ 560
DLED9 Net-_LED9-K_ Net-_D3-A_ LED_D_G
C20 0 Net-_D3-A_ 100n
R78 NET0066 NET0131 0
R16 NET0077 NET0014 0
R28 NET0045 NET0009 10
R45 NET0064 NET0060 10
C103 0 unconnected-_C103-Pad2_ 100n
C93 0 unconnected-_C93-Pad2_ 100n
C16 +3.3V 0 100n
R55 +3.3V Net-_U18-_WP__IO2__ 10k
R60 +3.3V Net-_U18-_HOLD__IO3__ 10k
C48 0 +3.3V 100n
C111 +3.3V 0 100n
C38 +3.3V 0 100n
C110 +3.3V 0 100n
C29 +3.3V 0 1u
C98 +3.3V 0 1u
C86 +3.3V 0 100n
C69 +3.3V 0 100n
C3 Net-_U13-C1_ 0 220n
R81 +3.3V NET0135 10k
C61 +3.3V 0 10u
R90 Net-_L1-Pad1_ Net-_U5-VCC_RF_ 10
C18 Net-_ANT2-Pad1_ Net-_U5-RF_IN_ 22p
C83 Net-_ANT2-Pad1_ 0 10n
L1 Net-_L1-Pad1_ Net-_ANT2-Pad1_ 27n
C71 +3.3V 0 100n
C91 +3.3V 0 100n
C36 Net-_U9-VO-_ Net-_U9-VO+_ 1n
C23 +3.3V 0 100n
R79 +3.3V NET0115 10k

V_3_3V +3.3V 0 DC 3.3
V_3V3 +3V3 0 DC 3.3
V_5V +5V 0 DC 5.0

.control
tran 100u 10m
set filetype=ascii
write Hades_raw.raw all
.endc

.end
