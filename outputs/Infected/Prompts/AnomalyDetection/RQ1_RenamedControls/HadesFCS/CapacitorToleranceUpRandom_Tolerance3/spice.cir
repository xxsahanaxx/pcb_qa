.title KiCad schematic

.model LED_D_G D (Is=1p Rs=10 N=1.7)
.model LED_D_B D (Is=1p Rs=10 N=1.7)
.model LED_D_Y D (Is=1p Rs=10 N=1.7)
.model LED_D_R D (Is=1p Rs=10 N=1.7)

R86 NET0056 VIN+ 0.01
C43 +3.3V 0 100n
C57 +5V NET0122 4.7n
L2 NET0097 +5V 15u
R63 +5V NET0122 6.8k
C88 +5V 0 47u
C17 +5V 0 100u
C7 NET0097 Net-_C7-Pad2_ 100n
R1 0 NET0122 1.3k
R44 Net-_C7-Pad2_ NET0122 19.6k
C1 NET0097 NET0169 100n
DLED5 Net-_LED5-K_ +5V LED_D_G
R3 0 Net-_LED5-K_ 560
R77 NET0100 Net-_D5-A_ 10k
C54 Net-_D5-A_ 0 2.2u
C31 Net-_REG3-PVDD_ 0 2.2u
R21 NET0056 NET0041 10k
C70 NET0056 0 100u
C23 NET0056 0 47u
R55 0 Net-_LED22-K_ 240
DLED22 Net-_LED22-K_ +3.3V LED_D_G
C33 +5V 0 10u
C46 +3.3V 0 10u
C11 NET0068 0 10p
C56 Net-_C56-Pad1_ 0 10p
R34 NET0049 Net-_C56-Pad1_ 620
C15 +3V3 0 100n
C90 +3V3 0 100n
R32 +3V3 NET0095 4.7k
R83 +3V3 NET0177 4.7k
R75 +3V3 NET0125 4.7k
R74 +3V3 NET0127 4.7k
C66 +3V3 0 100n
C97 +3V3 0 100n
DLED4 Net-_LED4-K_ NET0070 LED_D_B
R81 0 Net-_LED4-K_ 100
R19 +3V3 NET0043 4.7k
R64 +3V3 NET0110 4.7k
C74 VREF+_FCC 0 100n
R94 VREF+_FCC VDDA_FCC 47
C29 VDDA_FCC 0 100n
R85 0 Net-_LED13-K_ 330
R76 0 Net-_LED9-K_ 330
DLED6 Net-_LED6-K_ NET0142 LED_D_B
R37 0 Net-_LED6-K_ 100
C85 NET0009 0 100n
R56 0 Net-_LED18-K_ 330
DLED12 Net-_LED12-K_ NET0061 LED_D_B
DLED18 Net-_LED18-K_ NET0053 LED_D_Y
R51 0 Net-_LED12-K_ 100
DLED13 Net-_LED13-K_ NET0058 LED_D_R
DLED9 Net-_LED9-K_ NET0036 LED_D_R
C86 +3V3 0 100n
C48 +3V3 0 100n
C25 +3V3 0 100n
C21 +3V3 0 100n
C72 +3V3 0 100n
C2 +3V3 0 100n
C9 +3V3 0 100n
C110 Net-_FCC2-PH0_ 0 2.2u
C49 unconnected-_C49-Pad1_ 0 2.2u
R26 Net-_SW7-C_ NET0123 10k
R7 NET0134 Net-_C4-Pad1_ 620
C4 Net-_C4-Pad1_ 0 10p
C87 NET0105 0 10p
R25 +3V3 NET0135 4.7k
R78 +3V3 NET0092 4.7k
R16 +3V3 NET0078 4.7k
R67 +3V3 NET0161 4.7k
DLED15 Net-_LED15-K_ NET0003 LED_D_Y
DLED3 Net-_LED3-K_ NET0121 LED_D_B
R17 0 Net-_LED15-K_ 330
R42 0 Net-_LED3-K_ 100
DLED17 Net-_LED17-K_ NET0118 LED_D_R
R12 0 Net-_LED17-K_ 330
DLED11 Net-_LED11-K_ NET0103 LED_D_R
R14 0 Net-_LED11-K_ 330
C10 Net-_NAVC2-PH1_ 0 2.2u
C12 Net-_NAVC2-PH0_ 0 2.2u
C40 +3V3 0 100n
C65 +3V3 0 100n
C112 VDDA_NAVC 0 100n
C108 +3V3 0 100n
C5 +3V3 0 100n
C24 +3V3 0 100n
C3 +3V3 0 100n
C101 +3V3 0 100n
C14 +3V3 0 100n
C45 +3V3 0 100n
R15 Net-_SW4-C_ NET0072 10k
C82 NET0089 0 100n
R82 Net-_SW1-C_ NET0034 10k
R58 NET0156 NET0071 10
R36 NET0035 NET0170 10
R39 NET0158 NET0136 10
R59 NET0174 NET0128 10
R65 NET0114 NET0002 10
R31 NET0073 NET0059 10
R40 NET0107 NET0021 10
R49 NET0081 NET0018 10
R52 NET0028 Net-_USB4-D-_ 22
R28 NET0010 Net-_USB4-ID_ 560
R91 NET0075 Net-_USB4-D+_ 22
R9 NET0120 Net-_USB1-D+_ 22
R29 NET0091 Net-_USB1-D-_ 22
R87 NET0086 Net-_USB1-ID_ 560
DLED10 Net-_LED10-K_ Net-_D3-A_ LED_D_G
R22 0 Net-_LED10-K_ 560
C111 0 Net-_D3-A_ 100n
R89 0 Net-_LED19-K_ 560
DLED19 Net-_LED19-K_ Net-_D7-A_ LED_D_G
C8 0 Net-_D7-A_ 100n
R2 NET0175 NET0177 0
R48 NET0154 NET0127 0
R45 NET0090 NET0104 10
R62 NET0112 NET0069 10
C96 0 unconnected-_C96-Pad2_ 100n
C83 0 unconnected-_C83-Pad2_ 100n
C79 +3.3V 0 100n
R57 +3.3V Net-_U1-_WP__IO2__ 10k
R69 +3.3V Net-_U1-_HOLD__IO3__ 10k
C50 0 +3.3V 100n
C94 +3.3V 0 100n
C36 +3.3V 0 100n
C47 +3.3V 0 100n
C71 +3.3V 0 1u
C26 +3.3V 0 1u
C58 +3.3V 0 100n
C93 +3.3V 0 100n
C78 Net-_U12-C1_ 0 220n
R66 +3.3V NET0172 10k
C30 +3.3V 0 10u
R5 Net-_L3-Pad1_ Net-_U5-VCC_RF_ 10
C81 Net-_ANT2-Pad1_ Net-_U5-RF_IN_ 22p
C22 Net-_ANT2-Pad1_ 0 10n
L3 Net-_L3-Pad1_ Net-_ANT2-Pad1_ 27n
C106 +3.3V 0 100n
C20 +3.3V 0 100n
C34 Net-_U4-VO-_ Net-_U4-VO+_ 1n
C64 +3.3V 0 100n
R41 +3.3V NET0132 10k

V_3_3V +3.3V 0 DC 3.3
V_3V3 +3V3 0 DC 3.3
V_5V +5V 0 DC 5.0

.control
tran 100u 10m
set filetype=ascii
write Hades_raw.raw all
.endc

.end
