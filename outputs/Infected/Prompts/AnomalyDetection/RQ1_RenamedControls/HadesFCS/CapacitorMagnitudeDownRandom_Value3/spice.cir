.title KiCad schematic

.model LED_D_G D (Is=1p Rs=10 N=1.7)
.model LED_D_B D (Is=1p Rs=10 N=1.7)
.model LED_D_Y D (Is=1p Rs=10 N=1.7)
.model LED_D_R D (Is=1p Rs=10 N=1.7)

R23 NET0055 VIN+ 0.01
C101 +3.3V 0 100n
C14 +5V NET0169 4.7n
L2 NET0022 +5V 15u
R13 +5V NET0169 6.8k
C11 +5V 0 47u
C70 +5V 0 100u
C48 NET0022 Net-_C48-Pad2_ 100n
R89 0 NET0169 1.3k
R72 Net-_C48-Pad2_ NET0169 19.6k
C73 NET0022 NET0078 100n
DLED15 Net-_LED15-K_ +5V LED_D_G
R94 0 Net-_LED15-K_ 560
R61 NET0062 Net-_D3-A_ 10k
C86 Net-_D3-A_ 0 2.2u
C13 Net-_REG3-PVDD_ 0 2.2u
R71 NET0055 NET0030 10k
C64 NET0055 0 100u
C95 NET0055 0 47u
R54 0 Net-_LED7-K_ 240
DLED7 Net-_LED7-K_ +3.3V LED_D_G
C30 +5V 0 10u
C112 +3.3V 0 10u
C7 NET0059 0 10p
C83 Net-_C83-Pad1_ 0 10p
R25 NET0135 Net-_C83-Pad1_ 620
C43 +3V3 0 100n
C84 +3V3 0 100n
R82 +3V3 NET0105 4.7k
R32 +3V3 NET0009 4.7k
R30 +3V3 NET0150 4.7k
R73 +3V3 NET0103 4.7k
C49 +3V3 0 100n
C79 +3V3 0 100n
DLED3 Net-_LED3-K_ NET0023 LED_D_B
R69 0 Net-_LED3-K_ 100
R15 +3V3 NET0174 4.7k
R64 +3V3 NET0071 4.7k
C16 VREF+_FCC 0 100n
R42 VREF+_FCC VDDA_FCC 47
C107 VDDA_FCC 0 100n
R29 0 Net-_LED12-K_ 330
R11 0 Net-_LED2-K_ 330
DLED6 Net-_LED6-K_ NET0051 LED_D_B
R51 0 Net-_LED6-K_ 100
C94 NET0138 0 100n
R9 0 Net-_LED13-K_ 330
DLED17 Net-_LED17-K_ NET0163 LED_D_B
DLED13 Net-_LED13-K_ NET0101 LED_D_Y
R86 0 Net-_LED17-K_ 100
DLED12 Net-_LED12-K_ NET0124 LED_D_R
DLED2 Net-_LED2-K_ NET0033 LED_D_R
C24 +3V3 0 100n
C27 +3V3 0 100n
C32 +3V3 0 100n
C91 +3V3 0 100n
C3 +3V3 0 100n
C22 +3V3 0 100n
C97 +3V3 0 100n
C50 Net-_FCC2-PH0_ 0 2.2u
C17 unconnected-_C17-Pad1_ 0 2.2u
R65 Net-_SW4-C_ NET0064 10k
R7 NET0104 Net-_C56-Pad1_ 620
C56 Net-_C56-Pad1_ 0 10p
C18 NET0092 0 10p
R49 +3V3 NET0005 4.7k
R21 +3V3 NET0043 4.7k
R84 +3V3 NET0050 4.7k
R78 +3V3 NET0025 4.7k
DLED4 Net-_LED4-K_ NET0082 LED_D_Y
DLED16 Net-_LED16-K_ NET0153 LED_D_B
R63 0 Net-_LED4-K_ 330
R92 0 Net-_LED16-K_ 100
DLED14 Net-_LED14-K_ NET0122 LED_D_R
R1 0 Net-_LED14-K_ 330
DLED5 Net-_LED5-K_ NET0108 LED_D_R
R31 0 Net-_LED5-K_ 330
C100 Net-_NAVC2-PH1_ 0 2.2u
C38 Net-_NAVC2-PH0_ 0 2.2u
C68 +3V3 0 100n
C66 +3V3 0 100n
C23 VDDA_NAVC 0 100n
C12 +3V3 0 100n
C40 +3V3 0 100n
C19 +3V3 0 100n
C74 +3V3 0 100n
C85 +3V3 0 100n
C113 +3V3 0 100n
C1 +3V3 0 100n
R85 Net-_SW1-C_ NET0073 10k
C26 NET0012 0 100n
R68 Net-_SW7-C_ NET0151 10k
R12 NET0066 NET0127 10
R77 NET0026 NET0142 10
R19 NET0118 NET0113 10
R67 NET0074 NET0041 10
R87 NET0089 NET0020 10
R58 NET0148 NET0029 10
R39 NET0004 NET0160 10
R62 NET0008 NET0161 10
R70 NET0112 Net-_USB2-D-_ 22
R93 NET0069 Net-_USB2-ID_ 560
R57 NET0140 Net-_USB2-D+_ 22
R5 NET0083 Net-_USB6-D+_ 22
R48 NET0065 Net-_USB6-D-_ 22
R75 NET0002 Net-_USB6-ID_ 560
C2 0 unconnected-_C2-Pad2_ 100n
C8 0 Net-_D6-A_ 100n
DLED1 Net-_LED1-K_ Net-_D6-A_ LED_D_G
R66 0 Net-_LED1-K_ 560
C93 0 unconnected-_C93-Pad2_ 100n
C55 0 Net-_D1-A_ 100n
DLED8 Net-_LED8-K_ Net-_D1-A_ LED_D_G
R8 0 Net-_LED8-K_ 560
R47 NET0035 NET0044 10
R3 NET0121 NET0117 10
R91 NET0081 NET0009 0
R4 NET0085 NET0103 0
C71 +3.3V 0 100n
R6 +3.3V Net-_U2-_WP__IO2__ 10k
R45 +3.3V Net-_U2-_HOLD__IO3__ 10k
C45 0 +3.3V 100n
C5 +3.3V 0 100n
C52 +3.3V 0 100n
C34 +3.3V 0 100n
C37 +3.3V 0 1u
C46 +3.3V 0 1u
C35 +3.3V 0 100n
C6 +3.3V 0 100n
C67 Net-_U10-C1_ 0 220n
R55 +3.3V NET0155 10k
C102 +3.3V 0 10u
R40 Net-_L3-Pad1_ Net-_U4-VCC_RF_ 10
C42 Net-_ANT2-Pad1_ Net-_U4-RF_IN_ 22p
C106 Net-_ANT2-Pad1_ 0 10n
L3 Net-_L3-Pad1_ Net-_ANT2-Pad1_ 27n
C98 +3.3V 0 100n
C15 +3.3V 0 100n
C39 Net-_U17-VO-_ Net-_U17-VO+_ 1n
C111 +3.3V 0 100n
R74 +3.3V NET0157 10k

V_3_3V +3.3V 0 DC 3.3
V_3V3 +3V3 0 DC 3.3
V_5V +5V 0 DC 5.0

.control
tran 100u 10m
set filetype=ascii
write Hades_raw.raw all
.endc

.end
