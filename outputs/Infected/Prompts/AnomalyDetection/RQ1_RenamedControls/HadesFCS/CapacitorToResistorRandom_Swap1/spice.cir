.title KiCad schematic

.model LED_D_G D (Is=1p Rs=10 N=1.7)
.model LED_D_B D (Is=1p Rs=10 N=1.7)
.model LED_D_Y D (Is=1p Rs=10 N=1.7)
.model LED_D_R D (Is=1p Rs=10 N=1.7)

R15 NET0158 VIN+ 0.01
C32 +3.3V 0 100n
C21 +5V NET0081 4.7n
L3 NET0074 +5V 15u
R27 +5V NET0081 6.8k
C81 +5V 0 47u
C96 +5V 0 100u
C4 NET0074 Net-_C4-Pad2_ 100n
R24 0 NET0081 1.3k
R47 Net-_C4-Pad2_ NET0081 19.6k
C25 NET0074 NET0068 100n
DLED12 Net-_LED12-K_ +5V LED_D_G
R25 0 Net-_LED12-K_ 560
R43 NET0174 Net-_D4-A_ 10k
C53 Net-_D4-A_ 0 2.2u
C24 Net-_REG2-PVDD_ 0 2.2u
R68 NET0158 NET0062 10k
C56 NET0158 0 100u
C34 NET0158 0 47u
R84 0 Net-_LED17-K_ 240
DLED17 Net-_LED17-K_ +3.3V LED_D_G
C50 +5V 0 10u
C84 +3.3V 0 10u
C29 NET0100 0 10p
C89 Net-_C89-Pad1_ 0 10p
R62 NET0005 Net-_C89-Pad1_ 620
C14 +3V3 0 100n
C2 +3V3 0 100n
R37 +3V3 NET0091 4.7k
R1 +3V3 NET0160 4.7k
R78 +3V3 NET0117 4.7k
C28 +3V3 0 100n
R5 +3V3 NET0051 4.7k
C36 +3V3 0 100n
DLED10 Net-_LED10-K_ NET0025 LED_D_B
R51 0 Net-_LED10-K_ 100
R20 +3V3 NET0055 4.7k
R58 +3V3 NET0026 4.7k
C110 VREF+_FCC 0 100n
R94 VREF+_FCC VDDA_FCC 47
C95 VDDA_FCC 0 100n
R9 0 Net-_LED22-K_ 330
R46 0 Net-_LED20-K_ 330
DLED5 Net-_LED5-K_ NET0080 LED_D_B
R88 0 Net-_LED5-K_ 100
C27 NET0172 0 100n
R53 0 Net-_LED1-K_ 330
DLED2 Net-_LED2-K_ NET0007 LED_D_B
DLED1 Net-_LED1-K_ NET0044 LED_D_Y
R11 0 Net-_LED2-K_ 100
DLED22 Net-_LED22-K_ NET0039 LED_D_R
DLED20 Net-_LED20-K_ NET0041 LED_D_R
C82 +3V3 0 100n
C18 +3V3 0 100n
C19 +3V3 0 100n
C26 +3V3 0 100n
C74 +3V3 0 100n
C44 +3V3 0 100n
C62 +3V3 0 100n
C37 Net-_FCC2-PH0_ 0 2.2u
C10 unconnected-_C10-Pad1_ 0 2.2u
R14 Net-_SW8-C_ NET0153 10k
R59 NET0152 Net-_C102-Pad1_ 620
C102 Net-_C102-Pad1_ 0 10p
C106 NET0010 0 10p
R40 +3V3 NET0038 4.7k
R52 +3V3 NET0127 4.7k
R22 +3V3 NET0040 4.7k
R79 +3V3 NET0052 4.7k
DLED16 Net-_LED16-K_ NET0077 LED_D_Y
DLED6 Net-_LED6-K_ NET0004 LED_D_B
R54 0 Net-_LED16-K_ 330
R60 0 Net-_LED6-K_ 100
DLED21 Net-_LED21-K_ NET0142 LED_D_R
R2 0 Net-_LED21-K_ 330
DLED18 Net-_LED18-K_ NET0087 LED_D_R
R61 0 Net-_LED18-K_ 330
C112 Net-_NAVC2-PH1_ 0 2.2u
C33 Net-_NAVC2-PH0_ 0 2.2u
C63 +3V3 0 100n
C93 +3V3 0 100n
C55 VDDA_NAVC 0 100n
C65 +3V3 0 100n
C30 +3V3 0 100n
C75 +3V3 0 100n
C76 +3V3 0 100n
C8 +3V3 0 100n
C90 +3V3 0 100n
C54 +3V3 0 100n
R90 Net-_SW2-C_ NET0156 10k
C66 NET0047 0 100n
R13 Net-_SW5-C_ NET0101 10k
R73 NET0162 NET0145 10
R49 NET0019 NET0085 10
R19 NET0008 NET0121 10
R42 NET0031 NET0164 10
R91 NET0148 NET0078 10
R4 NET0024 NET0175 10
R70 NET0109 NET0173 10
R83 NET0059 NET0124 10
R87 NET0103 Net-_USB3-D-_ 22
R89 NET0083 Net-_USB3-ID_ 560
R93 NET0072 Net-_USB3-D+_ 22
R30 NET0017 Net-_USB4-D+_ 22
R57 NET0037 Net-_USB4-D-_ 22
R82 NET0096 Net-_USB4-ID_ 560
DLED19 Net-_LED19-K_ Net-_D3-A_ LED_D_G
R75 0 Net-_LED19-K_ 560
C87 0 Net-_D3-A_ 100n
R26 0 Net-_LED7-K_ 560
DLED7 Net-_LED7-K_ Net-_D8-A_ LED_D_G
C20 0 Net-_D8-A_ 100n
R21 NET0129 NET0051 0
R92 NET0128 NET0117 0
R10 NET0073 NET0093 10
R66 NET0001 NET0133 10
C45 0 unconnected-_C45-Pad2_ 100n
C9 0 unconnected-_C9-Pad2_ 100n
C6 +3.3V 0 100n
R41 +3.3V Net-_U16-_WP__IO2__ 10k
R56 +3.3V Net-_U16-_HOLD__IO3__ 10k
C51 0 +3.3V 100n
C48 +3.3V 0 100n
C16 +3.3V 0 100n
C11 +3.3V 0 100n
C101 +3.3V 0 1u
C46 +3.3V 0 1u
C72 +3.3V 0 100n
C107 +3.3V 0 100n
C57 Net-_U1-C1_ 0 220n
R76 +3.3V NET0057 10k
C39 +3.3V 0 10u
R8 Net-_L1-Pad1_ Net-_U13-VCC_RF_ 10
C5 Net-_ANT2-Pad1_ Net-_U13-RF_IN_ 22p
C88 Net-_ANT2-Pad1_ 0 10n
L1 Net-_L1-Pad1_ Net-_ANT2-Pad1_ 27n
C41 +3.3V 0 100n
C67 +3.3V 0 100n
C91 Net-_U9-VO-_ Net-_U9-VO+_ 1n
C13 +3.3V 0 100n
R28 +3.3V NET0119 10k

V_3_3V +3.3V 0 DC 3.3
V_3V3 +3V3 0 DC 3.3
V_5V +5V 0 DC 5.0

.control
tran 100u 10m
set filetype=ascii
write Hades_raw.raw all
.endc

.end
