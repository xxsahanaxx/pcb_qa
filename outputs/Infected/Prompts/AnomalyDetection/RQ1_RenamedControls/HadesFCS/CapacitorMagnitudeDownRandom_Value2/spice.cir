.title KiCad schematic

.model LED_D_G D (Is=1p Rs=10 N=1.7)
.model LED_D_B D (Is=1p Rs=10 N=1.7)
.model LED_D_Y D (Is=1p Rs=10 N=1.7)
.model LED_D_R D (Is=1p Rs=10 N=1.7)

R43 NET0085 VIN+ 0.01
C37 +3.3V 0 100n
C38 +5V NET0072 4.7n
L2 NET0030 +5V 15u
R10 +5V NET0072 6.8k
C76 +5V 0 47u
C73 +5V 0 100u
C22 NET0030 Net-_C22-Pad2_ 100n
R61 0 NET0072 1.3k
R80 Net-_C22-Pad2_ NET0072 19.6k
C29 NET0030 NET0117 100n
DLED6 Net-_LED6-K_ +5V LED_D_G
R6 0 Net-_LED6-K_ 560
R63 NET0157 Net-_D4-A_ 10k
C34 Net-_D4-A_ 0 2.2u
C27 NET0085 0 100u
C105 NET0085 0 47u
R60 NET0085 NET0152 10k
C2 Net-_REG2-PVDD_ 0 2.2u
R58 0 Net-_LED7-K_ 240
DLED7 Net-_LED7-K_ +3.3V LED_D_G
C13 +5V 0 10u
C77 +3.3V 0 10u
C55 NET0104 0 10p
C20 Net-_C20-Pad1_ 0 10p
R39 NET0062 Net-_C20-Pad1_ 620
C18 +3V3 0 100n
C42 +3V3 0 100n
R2 +3V3 NET0099 4.7k
R19 +3V3 NET0172 4.7k
R45 +3V3 NET0069 4.7k
R85 +3V3 NET0121 4.7k
C79 +3V3 0 100n
C48 +3V3 0 100n
DLED14 Net-_LED14-K_ NET0076 LED_D_B
R5 0 Net-_LED14-K_ 100
R35 +3V3 NET0165 4.7k
R18 +3V3 NET0050 4.7k
C67 VREF+_FCC 0 100n
R87 VREF+_FCC VDDA_FCC 47
C101 VDDA_FCC 0 100n
R54 0 Net-_LED16-K_ 330
R88 0 Net-_LED9-K_ 330
DLED2 Net-_LED2-K_ NET0143 LED_D_B
R1 0 Net-_LED2-K_ 100
C36 NET0170 0 100n
R9 0 Net-_LED22-K_ 330
DLED13 Net-_LED13-K_ NET0093 LED_D_B
DLED22 Net-_LED22-K_ NET0023 LED_D_Y
R62 0 Net-_LED13-K_ 100
DLED16 Net-_LED16-K_ NET0055 LED_D_R
DLED9 Net-_LED9-K_ NET0035 LED_D_R
C17 +3V3 0 100n
C112 +3V3 0 100n
C56 +3V3 0 100n
C63 +3V3 0 100n
C113 +3V3 0 100n
C4 +3V3 0 100n
C81 +3V3 0 100n
C43 Net-_FCC2-PH0_ 0 2.2u
C62 unconnected-_C62-Pad1_ 0 2.2u
R36 Net-_SW1-C_ NET0056 10k
R94 NET0176 Net-_C109-Pad1_ 620
C109 Net-_C109-Pad1_ 0 10p
C102 NET0125 0 10p
R69 +3V3 NET0155 4.7k
R65 +3V3 NET0096 4.7k
R86 +3V3 NET0040 4.7k
R25 +3V3 NET0073 4.7k
DLED3 Net-_LED3-K_ NET0064 LED_D_Y
DLED17 Net-_LED17-K_ NET0022 LED_D_B
R90 0 Net-_LED3-K_ 330
R11 0 Net-_LED17-K_ 100
DLED20 Net-_LED20-K_ NET0106 LED_D_R
R32 0 Net-_LED20-K_ 330
DLED8 Net-_LED8-K_ NET0116 LED_D_R
R70 0 Net-_LED8-K_ 330
C69 Net-_NAVC2-PH1_ 0 2.2u
C103 Net-_NAVC2-PH0_ 0 2.2u
C74 +3V3 0 100n
C99 +3V3 0 100n
C86 VDDA_NAVC 0 100n
C80 +3V3 0 100n
C6 +3V3 0 100n
C83 +3V3 0 100n
C84 +3V3 0 100n
C91 +3V3 0 100n
C58 +3V3 0 100n
C45 +3V3 0 100n
R55 Net-_SW4-C_ NET0171 10k
C110 NET0051 0 100n
R7 Net-_SW5-C_ NET0098 10k
R22 NET0136 NET0131 10
R71 NET0139 NET0090 10
R15 NET0067 NET0015 10
R78 NET0046 NET0082 10
R92 NET0016 NET0019 10
R64 NET0014 NET0059 10
R33 NET0042 NET0156 10
R72 NET0118 NET0161 10
R40 NET0159 Net-_USB4-D-_ 22
R57 NET0166 Net-_USB4-ID_ 560
R12 NET0154 Net-_USB4-D+_ 22
R34 NET0033 Net-_USB3-D+_ 22
R46 NET0162 Net-_USB3-D-_ 22
R67 NET0149 Net-_USB3-ID_ 560
C70 0 unconnected-_C70-Pad2_ 100n
C23 0 Net-_D1-A_ 100n
DLED5 Net-_LED5-K_ Net-_D1-A_ LED_D_G
R37 0 Net-_LED5-K_ 560
C89 0 unconnected-_C89-Pad2_ 100n
C106 0 Net-_D2-A_ 100n
DLED19 Net-_LED19-K_ Net-_D2-A_ LED_D_G
R84 0 Net-_LED19-K_ 560
R14 NET0132 NET0140 10
R52 NET0008 NET0114 10
R73 NET0021 NET0172 0
R38 NET0065 NET0121 0
C61 +3.3V 0 100n
R91 +3.3V Net-_U11-_WP__IO2__ 10k
R76 +3.3V Net-_U11-_HOLD__IO3__ 10k
C41 0 +3.3V 100n
C50 +3.3V 0 100n
C14 +3.3V 0 100n
C53 +3.3V 0 100n
C88 +3.3V 0 1u
C104 +3.3V 0 1u
C12 +3.3V 0 100n
C21 +3.3V 0 100n
C11 Net-_U16-C1_ 0 220n
R31 +3.3V NET0032 10k
C44 +3.3V 0 10u
R68 Net-_L3-Pad1_ Net-_U7-VCC_RF_ 10
C60 Net-_ANT2-Pad1_ Net-_U7-RF_IN_ 22p
C31 Net-_ANT2-Pad1_ 0 10n
L3 Net-_L3-Pad1_ Net-_ANT2-Pad1_ 27n
C59 +3.3V 0 100n
C25 +3.3V 0 100n
C9 Net-_U18-VO-_ Net-_U18-VO+_ 1n
C3 +3.3V 0 100n
R48 +3.3V NET0138 10k

V_3_3V +3.3V 0 DC 3.3
V_3V3 +3V3 0 DC 3.3
V_5V +5V 0 DC 5.0

.control
tran 100u 10m
set filetype=ascii
write Hades_raw.raw all
.endc

.end
