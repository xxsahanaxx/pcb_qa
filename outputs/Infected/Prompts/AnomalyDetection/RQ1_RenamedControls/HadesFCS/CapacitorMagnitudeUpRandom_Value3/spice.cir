.title KiCad schematic

.model LED_D_G D (Is=1p Rs=10 N=1.7)
.model LED_D_B D (Is=1p Rs=10 N=1.7)
.model LED_D_Y D (Is=1p Rs=10 N=1.7)
.model LED_D_R D (Is=1p Rs=10 N=1.7)

R52 NET0131 VIN+ 0.01
C90 +3.3V 0 100n
C85 +5V NET0011 4.7n
L2 NET0050 +5V 15u
R9 +5V NET0011 6.8k
C3 +5V 0 47u
C75 +5V 0 100u
C43 NET0050 Net-_C43-Pad2_ 100n
R89 0 NET0011 1.3k
R79 Net-_C43-Pad2_ NET0011 19.6k
C41 NET0050 NET0134 100n
DLED2 Net-_LED2-K_ +5V LED_D_G
R57 0 Net-_LED2-K_ 560
R78 NET0141 Net-_D5-A_ 10k
C110 Net-_D5-A_ 0 2.2u
C111 Net-_REG3-PVDD_ 0 2.2u
R85 NET0131 NET0044 10k
C60 NET0131 0 100u
C35 NET0131 0 47u
R59 0 Net-_LED4-K_ 240
DLED4 Net-_LED4-K_ +3.3V LED_D_G
C32 +5V 0 10u
C63 +3.3V 0 10u
C15 NET0103 0 10p
C11 Net-_C11-Pad1_ 0 10p
R81 NET0109 Net-_C11-Pad1_ 620
C25 +3V3 0 100n
C107 +3V3 0 100n
R67 +3V3 NET0027 4.7k
R25 +3V3 NET0149 4.7k
R7 +3V3 NET0023 4.7k
R60 +3V3 NET0015 4.7k
C76 +3V3 0 100n
C79 +3V3 0 100n
DLED19 Net-_LED19-K_ NET0110 LED_D_B
R41 0 Net-_LED19-K_ 100
R5 +3V3 NET0017 4.7k
R32 +3V3 NET0114 4.7k
C31 VREF+_FCC 0 100n
R31 VREF+_FCC VDDA_FCC 47
C104 VDDA_FCC 0 100n
R55 0 Net-_LED1-K_ 330
R86 0 Net-_LED15-K_ 330
DLED12 Net-_LED12-K_ NET0100 LED_D_B
R11 0 Net-_LED12-K_ 100
C38 NET0070 0 100n
R62 0 Net-_LED16-K_ 330
DLED5 Net-_LED5-K_ NET0065 LED_D_B
DLED16 Net-_LED16-K_ NET0076 LED_D_Y
R75 0 Net-_LED5-K_ 100
DLED1 Net-_LED1-K_ NET0095 LED_D_R
DLED15 Net-_LED15-K_ NET0173 LED_D_R
C81 +3V3 0 100n
C106 +3V3 0 100n
C86 +3V3 0 100n
C20 +3V3 0 100n
C46 +3V3 0 100n
C101 +3V3 0 100n
C59 +3V3 0 100n
C67 Net-_FCC2-PH0_ 0 2.2u
C73 unconnected-_C73-Pad1_ 0 2.2u
R46 Net-_SW8-C_ NET0120 10k
R66 NET0111 Net-_C95-Pad1_ 620
C95 Net-_C95-Pad1_ 0 10p
C51 NET0169 0 10p
R19 +3V3 NET0139 4.7k
R58 +3V3 NET0068 4.7k
R48 +3V3 NET0119 4.7k
R76 +3V3 NET0174 4.7k
DLED14 Net-_LED14-K_ NET0042 LED_D_Y
DLED13 Net-_LED13-K_ NET0072 LED_D_B
R80 0 Net-_LED14-K_ 330
R8 0 Net-_LED13-K_ 100
DLED20 Net-_LED20-K_ NET0097 LED_D_R
R61 0 Net-_LED20-K_ 330
DLED10 Net-_LED10-K_ NET0083 LED_D_R
R88 0 Net-_LED10-K_ 330
C65 Net-_NAVC2-PH1_ 0 2.2u
C70 Net-_NAVC2-PH0_ 0 2.2u
C23 +3V3 0 100n
C37 +3V3 0 100n
C9 VDDA_NAVC 0 100n
C108 +3V3 0 100n
C102 +3V3 0 100n
C98 +3V3 0 100n
C29 +3V3 0 100n
C78 +3V3 0 100n
C50 +3V3 0 100n
C100 +3V3 0 100n
R65 Net-_SW5-C_ NET0117 10k
C54 NET0102 0 100n
R16 Net-_SW2-C_ NET0090 10k
R54 NET0123 NET0160 10
R15 NET0010 NET0154 10
R38 NET0005 NET0144 10
R18 NET0170 NET0107 10
R77 NET0082 NET0034 10
R51 NET0143 NET0172 10
R30 NET0124 NET0073 10
R94 NET0037 NET0035 10
R42 NET0036 Net-_USB4-D-_ 22
R14 NET0059 Net-_USB4-ID_ 560
R29 NET0062 Net-_USB4-D+_ 22
R26 NET0054 Net-_USB1-D+_ 22
R45 NET0162 Net-_USB1-D-_ 22
R39 NET0024 Net-_USB1-ID_ 560
C34 0 unconnected-_C34-Pad2_ 100n
C62 0 Net-_D6-A_ 100n
DLED3 Net-_LED3-K_ Net-_D6-A_ LED_D_G
R34 0 Net-_LED3-K_ 560
C7 0 unconnected-_C7-Pad2_ 100n
C52 0 Net-_D4-A_ 100n
DLED6 Net-_LED6-K_ Net-_D4-A_ LED_D_G
R68 0 Net-_LED6-K_ 560
R37 NET0130 NET0004 10
R71 NET0081 NET0022 10
R22 NET0168 NET0149 0
R70 NET0158 NET0015 0
C17 +3.3V 0 100n
R35 +3.3V Net-_U1-_WP__IO2__ 10k
R44 +3.3V Net-_U1-_HOLD__IO3__ 10k
C14 0 +3.3V 100n
C36 +3.3V 0 100n
C61 +3.3V 0 100n
C2 +3.3V 0 100n
C82 +3.3V 0 1u
C109 +3.3V 0 1u
C22 +3.3V 0 100n
C103 +3.3V 0 100n
C48 Net-_U9-C1_ 0 220n
R73 +3.3V NET0051 10k
C72 +3.3V 0 10u
R91 Net-_L3-Pad1_ Net-_U4-VCC_RF_ 10
C47 Net-_ANT2-Pad1_ Net-_U4-RF_IN_ 22p
C105 Net-_ANT2-Pad1_ 0 10n
L3 Net-_L3-Pad1_ Net-_ANT2-Pad1_ 27n
C40 +3.3V 0 100n
C88 +3.3V 0 100n
C89 Net-_U15-VO-_ Net-_U15-VO+_ 1n
C8 +3.3V 0 100n
R69 +3.3V NET0148 10k

V_3_3V +3.3V 0 DC 3.3
V_3V3 +3V3 0 DC 3.3
V_5V +5V 0 DC 5.0

.control
tran 100u 10m
set filetype=ascii
write Hades_raw.raw all
.endc

.end
