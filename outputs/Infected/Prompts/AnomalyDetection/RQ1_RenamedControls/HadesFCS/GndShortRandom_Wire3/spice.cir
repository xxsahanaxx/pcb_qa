.title KiCad schematic

.model LED_D_G D (Is=1p Rs=10 N=1.7)
.model LED_D_B D (Is=1p Rs=10 N=1.7)
.model LED_D_Y D (Is=1p Rs=10 N=1.7)
.model LED_D_R D (Is=1p Rs=10 N=1.7)

R38 NET0113 VIN+ 0.01
C56 +3.3V 0 100n
C11 +5V NET0075 4.7n
L2 NET0116 +5V 15u
R13 +5V NET0075 6.8k
C91 +5V 0 47u
C72 +5V 0 100u
C70 NET0116 Net-_C70-Pad2_ 100n
R67 0 NET0075 1.3k
R27 Net-_C70-Pad2_ NET0075 19.6k
C110 NET0116 NET0103 100n
DLED22 Net-_LED22-K_ +5V LED_D_G
R60 0 Net-_LED22-K_ 560
R52 NET0010 Net-_D4-A_ 10k
C69 Net-_D4-A_ 0 2.2u
C19 Net-_REG2-PVDD_ 0 2.2u
R3 NET0113 NET0057 10k
C106 NET0113 0 100u
C9 NET0113 0 47u
R23 0 Net-_LED12-K_ 240
DLED12 Net-_LED12-K_ +3.3V LED_D_G
C60 +5V 0 10u
C61 +3.3V 0 10u
C92 NET0059 0 10p
C93 Net-_C93-Pad1_ 0 10p
R45 NET0090 Net-_C93-Pad1_ 620
C101 +3V3 0 100n
C81 +3V3 0 100n
R50 +3V3 NET0102 4.7k
R37 +3V3 NET0042 4.7k
R24 +3V3 NET0051 4.7k
R57 +3V3 NET0004 4.7k
C108 +3V3 0 100n
C6 +3V3 0 100n
DLED13 Net-_LED13-K_ NET0081 LED_D_B
R49 0 Net-_LED13-K_ 100
R20 +3V3 NET0036 4.7k
R94 +3V3 NET0118 4.7k
C78 VREF+_FCC 0 100n
R8 VREF+_FCC VDDA_FCC 47
C23 VDDA_FCC 0 100n
R93 0 Net-_LED20-K_ 330
R41 0 Net-_LED19-K_ 330
DLED3 Net-_LED3-K_ NET0037 LED_D_B
R29 0 Net-_LED3-K_ 100
C50 NET0029 0 100n
R92 0 Net-_LED21-K_ 330
DLED14 Net-_LED14-K_ NET0088 LED_D_B
DLED21 Net-_LED21-K_ NET0136 LED_D_Y
R36 0 Net-_LED14-K_ 100
DLED20 Net-_LED20-K_ NET0151 LED_D_R
DLED19 Net-_LED19-K_ NET0041 LED_D_R
C41 +3V3 0 100n
C75 +3V3 0 100n
C99 +3V3 0 100n
C65 +3V3 0 100n
C35 +3V3 0 100n
C84 +3V3 0 100n
C104 +3V3 0 100n
C33 Net-_FCC2-PH0_ 0 2.2u
C24 unconnected-_C24-Pad1_ 0 2.2u
R18 Net-_SW1-C_ NET0003 10k
R7 NET0170 Net-_C83-Pad1_ 620
C83 Net-_C83-Pad1_ 0 10p
C62 NET0167 0 10p
R14 +3V3 NET0025 4.7k
R2 +3V3 NET0082 4.7k
R70 +3V3 NET0012 4.7k
R44 +3V3 NET0091 4.7k
DLED10 Net-_LED10-K_ NET0008 LED_D_Y
DLED2 Net-_LED2-K_ NET0129 LED_D_B
R5 0 Net-_LED10-K_ 330
R76 0 Net-_LED2-K_ 100
DLED9 Net-_LED9-K_ NET0050 LED_D_R
R69 0 Net-_LED9-K_ 330
DLED5 Net-_LED5-K_ NET0112 LED_D_R
R53 0 Net-_LED5-K_ 330
C95 Net-_NAVC2-PH1_ 0 2.2u
C44 Net-_NAVC2-PH0_ 0 2.2u
C42 +3V3 0 100n
C82 +3V3 0 100n
C36 VDDA_NAVC 0 100n
C1 +3V3 0 100n
C38 +3V3 0 100n
C87 +3V3 0 100n
C67 +3V3 0 100n
C37 +3V3 0 100n
C80 +3V3 0 100n
C45 +3V3 0 100n
R16 Net-_SW2-C_ NET0169 10k
C8 NET0015 0 100n
R62 Net-_SW8-C_ NET0160 10k
R21 NET0168 NET0071 10
R75 NET0038 NET0162 10
R15 NET0018 NET0060 10
R46 NET0115 NET0024 10
R28 NET0085 NET0101 10
R61 NET0093 NET0137 10
R32 NET0131 NET0135 10
R83 NET0120 NET0105 10
R4 NET0052 Net-_USB4-D-_ 22
R80 NET0148 Net-_USB4-ID_ 560
R78 NET0089 Net-_USB4-D+_ 22
R9 NET0095 Net-_USB3-D+_ 22
R59 NET0140 Net-_USB3-D-_ 22
R74 NET0121 Net-_USB3-ID_ 560
C28 0 unconnected-_C28-Pad2_ 100n
C85 0 Net-_D7-A_ 100n
DLED1 Net-_LED1-K_ Net-_D7-A_ LED_D_G
R84 0 Net-_LED1-K_ 560
C29 0 unconnected-_C29-Pad2_ 100n
C30 0 Net-_D3-A_ 100n
DLED7 Net-_LED7-K_ Net-_D3-A_ LED_D_G
R33 0 Net-_LED7-K_ 560
R91 NET0124 NET0061 10
R10 NET0134 NET0073 10
R48 NET0110 NET0042 0
R82 NET0127 NET0004 0
C43 +3.3V 0 100n
R58 +3.3V Net-_U17-_WP__IO2__ 10k
R47 +3.3V Net-_U17-_HOLD__IO3__ 10k
C47 0 +3.3V 100n
C111 +3.3V 0 100n
C77 +3.3V 0 100n
C3 +3.3V 0 100n
C13 +3.3V 0 1u
C10 +3.3V 0 1u
C96 +3.3V 0 100n
C17 +3.3V 0 100n
C73 Net-_U18-C1_ 0 220n
R30 +3.3V NET0100 10k
C58 +3.3V 0 10u
R64 Net-_L3-Pad1_ Net-_U1-VCC_RF_ 10
C34 Net-_ANT2-Pad1_ Net-_U1-RF_IN_ 22p
C12 Net-_ANT2-Pad1_ 0 10n
L3 Net-_L3-Pad1_ Net-_ANT2-Pad1_ 27n
C53 +3.3V 0 100n
C89 +3.3V 0 100n
C52 Net-_U5-VO-_ Net-_U5-VO+_ 1n
C76 +3.3V 0 100n
R65 +3.3V NET0138 10k

V_3_3V +3.3V 0 DC 3.3
V_3V3 +3V3 0 DC 3.3
V_5V +5V 0 DC 5.0

.control
tran 100u 10m
set filetype=ascii
write Hades_raw.raw all
.endc

.end
