.title KiCad schematic

.model LED_D_G D (Is=1p Rs=10 N=1.7)
.model LED_D_B D (Is=1p Rs=10 N=1.7)
.model LED_D_Y D (Is=1p Rs=10 N=1.7)
.model LED_D_R D (Is=1p Rs=10 N=1.7)

R36 NET0176 VIN+ 0.01
C50 +3.3V 0 100n
C97 +5V NET0115 4.7n
L2 NET0033 +5V 15u
R52 +5V NET0115 6.8k
C86 +5V 0 47u
C28 +5V 0 100u
C22 NET0033 Net-_C22-Pad2_ 100n
R17 0 NET0115 1.3k
R56 Net-_C22-Pad2_ NET0115 19.6k
C56 NET0033 NET0130 100n
DLED14 Net-_LED14-K_ +5V LED_D_G
R44 0 Net-_LED14-K_ 560
R88 NET0120 Net-_D4-A_ 10k
C99 Net-_D4-A_ 0 2.2u
C67 Net-_REG2-PVDD_ 0 2.2u
R84 NET0176 NET0102 10k
C2 NET0176 0 100u
C63 NET0176 0 47u
R89 0 Net-_LED13-K_ 240
DLED13 Net-_LED13-K_ +3.3V LED_D_G
C80 +5V 0 10u
C33 +3.3V 0 10u
C110 NET0041 0 10p
C19 Net-_C19-Pad1_ 0 10p
R11 NET0149 Net-_C19-Pad1_ 620
C12 +3V3 0 100n
C49 +3V3 0 100n
R30 +3V3 NET0067 4.7k
R40 +3V3 NET0122 4.7k
R19 +3V3 NET0106 4.7k
R34 +3V3 NET0143 4.7k
C89 +3V3 0 100n
C107 +3V3 0 100n
DLED22 Net-_LED22-K_ NET0070 LED_D_B
R5 0 Net-_LED22-K_ 100
R15 +3V3 NET0135 4.7k
R67 +3V3 NET0046 4.7k
C14 VREF+_FCC 0 100n
R59 VREF+_FCC VDDA_FCC 47
C5 VDDA_FCC 0 100n
R78 0 Net-_LED5-K_ 330
R49 0 Net-_LED12-K_ 330
DLED21 Net-_LED21-K_ NET0073 LED_D_B
R22 0 Net-_LED21-K_ 100
C87 NET0166 0 100n
R81 0 Net-_LED11-K_ 330
DLED15 Net-_LED15-K_ NET0037 LED_D_B
DLED11 Net-_LED11-K_ NET0174 LED_D_Y
R65 0 Net-_LED15-K_ 100
DLED5 Net-_LED5-K_ NET0014 LED_D_R
DLED12 Net-_LED12-K_ NET0049 LED_D_R
C92 +3V3 0 100n
C51 +3V3 0 100n
C3 +3V3 0 100n
C29 +3V3 0 100n
C26 +3V3 0 100n
C81 +3V3 0 100n
C55 +3V3 0 100n
C31 Net-_FCC2-PH0_ 0 2.2u
C32 unconnected-_C32-Pad1_ 0 2.2u
R82 Net-_SW7-C_ NET0076 10k
R14 NET0138 Net-_C111-Pad1_ 620
C111 Net-_C111-Pad1_ 0 10p
C109 NET0118 0 10p
R90 +3V3 NET0012 4.7k
R62 +3V3 NET0004 4.7k
R50 +3V3 NET0125 4.7k
R38 +3V3 NET0003 4.7k
DLED8 Net-_LED8-K_ NET0108 LED_D_Y
DLED2 Net-_LED2-K_ NET0095 LED_D_B
R55 0 Net-_LED8-K_ 330
R79 0 Net-_LED2-K_ 100
DLED18 Net-_LED18-K_ NET0112 LED_D_R
R12 0 Net-_LED18-K_ 330
DLED16 Net-_LED16-K_ NET0071 LED_D_R
R61 0 Net-_LED16-K_ 330
C58 Net-_NAVC2-PH1_ 0 2.2u
C69 Net-_NAVC2-PH0_ 0 2.2u
C77 +3V3 0 100n
C62 +3V3 0 100n
C57 VDDA_NAVC 0 100n
C20 +3V3 0 100n
C95 +3V3 0 100n
C47 +3V3 0 100n
C4 +3V3 0 100n
C43 +3V3 0 100n
C65 +3V3 0 100n
C13 +3V3 0 100n
R37 Net-_SW6-C_ NET0022 10k
C8 NET0035 0 100n
R4 Net-_SW8-C_ NET0051 10k
R31 NET0090 NET0019 10
R7 NET0053 NET0153 10
R58 NET0025 NET0068 10
R73 NET0092 NET0177 10
R3 NET0047 NET0086 10
R18 NET0116 NET0097 10
R35 NET0107 NET0133 10
R10 NET0007 NET0056 10
R9 NET0144 Net-_USB5-D-_ 22
R41 NET0063 Net-_USB5-ID_ 560
R21 NET0089 Net-_USB5-D+_ 22
R45 NET0062 Net-_USB1-D+_ 22
R47 NET0058 Net-_USB1-D-_ 22
R24 NET0011 Net-_USB1-ID_ 560
C35 0 unconnected-_C35-Pad2_ 100n
C37 0 Net-_D8-A_ 100n
DLED7 Net-_LED7-K_ Net-_D8-A_ LED_D_G
R46 0 Net-_LED7-K_ 560
C101 0 unconnected-_C101-Pad2_ 100n
C73 0 Net-_D2-A_ 100n
DLED10 Net-_LED10-K_ Net-_D2-A_ LED_D_G
R28 0 Net-_LED10-K_ 560
R16 NET0162 NET0155 10
R33 NET0165 NET0128 10
R76 NET0031 NET0122 0
R63 NET0075 NET0143 0
C9 +3.3V 0 100n
R66 +3.3V Net-_U1-_WP__IO2__ 10k
R75 +3.3V Net-_U1-_HOLD__IO3__ 10k
C10 0 +3.3V 100n
C108 +3.3V 0 100n
C46 +3.3V 0 100n
C98 +3.3V 0 100n
C36 +3.3V 0 1u
C27 +3.3V 0 1u
C103 +3.3V 0 100n
C25 +3.3V 0 100n
C72 Net-_U3-C1_ 0 220n
R86 +3.3V NET0111 10k
C24 +3.3V 0 10u
R42 Net-_L3-Pad1_ Net-_U15-VCC_RF_ 10
C70 Net-_ANT2-Pad1_ Net-_U15-RF_IN_ 22p
C83 Net-_ANT2-Pad1_ 0 10n
L3 Net-_L3-Pad1_ Net-_ANT2-Pad1_ 27n
C30 +3.3V 0 100n
C60 +3.3V 0 100n
C40 Net-_U5-VO-_ Net-_U5-VO+_ 1n
C91 +3.3V 0 100n
R26 +3.3V NET0156 10k

V_3_3V +3.3V 0 DC 3.3
V_3V3 +3V3 0 DC 3.3
V_5V +5V 0 DC 5.0

.control
tran 100u 10m
set filetype=ascii
write Hades_raw.raw all
.endc

.end
