.title KiCad schematic

.model LED_D_G D (Is=1p Rs=10 N=1.7)
.model LED_D_B D (Is=1p Rs=10 N=1.7)
.model LED_D_Y D (Is=1p Rs=10 N=1.7)
.model LED_D_R D (Is=1p Rs=10 N=1.7)

R52 NET0092 VIN+ 0.01
C104 +3.3V 0 100n
C96 +5V NET0164 4.7n
L2 NET0119 +5V 15u
R62 +5V NET0164 6.8k
C63 +5V 0 47u
C18 +5V 0 100u
C51 NET0119 Net-_C51-Pad2_ 100n
R68 0 NET0164 1.3k
R54 Net-_C51-Pad2_ NET0164 19.6k
C53 NET0119 NET0045 100n
DLED13 Net-_LED13-K_ +5V LED_D_G
R49 0 Net-_LED13-K_ 560
R8 NET0149 Net-_D5-A_ 10k
C3 Net-_D5-A_ 0 2.2u
C12 Net-_REG2-PVDD_ 0 2.2u
R89 NET0092 NET0053 10k
C106 NET0092 0 100u
C7 NET0092 0 47u
R61 0 Net-_LED3-K_ 240
DLED3 Net-_LED3-K_ +3.3V LED_D_G
C59 +5V 0 10u
C24 +3.3V 0 10u
C58 NET0148 0 10p
C56 Net-_C56-Pad1_ 0 10p
R46 NET0016 Net-_C56-Pad1_ 620
C71 +3V3 0 100n
C19 +3V3 0 100n
R93 +3V3 NET0061 4.7k
R85 +3V3 NET0127 4.7k
R69 +3V3 NET0038 4.7k
R90 +3V3 NET0140 4.7k
C30 +3V3 0 100n
C76 +3V3 0 100n
DLED4 Net-_LED4-K_ NET0062 LED_D_B
R12 0 Net-_LED4-K_ 100
R84 +3V3 NET0028 4.7k
R88 +3V3 NET0041 4.7k
C2 VREF+_FCC 0 100n
R64 VREF+_FCC VDDA_FCC 47
C100 VDDA_FCC 0 100n
R21 0 Net-_LED19-K_ 330
R18 0 Net-_LED14-K_ 330
DLED18 Net-_LED18-K_ NET0010 LED_D_B
R45 0 Net-_LED18-K_ 100
C45 NET0067 0 100n
R78 0 Net-_LED11-K_ 330
DLED22 Net-_LED22-K_ NET0013 LED_D_B
DLED11 Net-_LED11-K_ NET0154 LED_D_Y
R53 0 Net-_LED22-K_ 100
DLED19 Net-_LED19-K_ NET0022 LED_D_R
DLED14 Net-_LED14-K_ NET0020 LED_D_R
C31 +3V3 0 100n
C108 +3V3 0 100n
C101 +3V3 0 100n
C88 +3V3 0 100n
C89 +3V3 0 100n
C6 +3V3 0 100n
C67 +3V3 0 100n
C109 Net-_FCC2-PH0_ 0 2.2u
C27 unconnected-_C27-Pad1_ 0 2.2u
R51 Net-_SW8-C_ NET0129 10k
R27 NET0011 Net-_C64-Pad1_ 620
C64 Net-_C64-Pad1_ 0 10p
C111 NET0030 0 10p
R94 +3V3 NET0042 4.7k
R82 +3V3 NET0048 4.7k
R9 +3V3 NET0059 4.7k
R4 +3V3 NET0057 4.7k
DLED1 Net-_LED1-K_ NET0157 LED_D_Y
DLED20 Net-_LED20-K_ NET0002 LED_D_B
R44 0 Net-_LED1-K_ 330
R30 0 Net-_LED20-K_ 100
R6 0 Net-_LED8-K_ 330
R36 0 Net-_LED12-K_ 330
DLED12 Net-_LED12-K_ NET0036 LED_D_R
DLED8 Net-_LED8-K_ NET0019 LED_D_R
C107 Net-_NAVC2-PH1_ 0 2.2u
C62 Net-_NAVC2-PH0_ 0 2.2u
C10 +3V3 0 100n
C49 +3V3 0 100n
C80 VDDA_NAVC 0 100n
C37 +3V3 0 100n
C16 +3V3 0 100n
C69 +3V3 0 100n
C97 +3V3 0 100n
C92 +3V3 0 100n
C60 +3V3 0 100n
C113 +3V3 0 100n
R32 Net-_SW4-C_ NET0175 10k
C38 NET0066 0 100n
R34 Net-_SW3-C_ NET0177 10k
R73 NET0086 NET0035 10
R19 NET0051 NET0176 10
R13 NET0155 NET0012 10
R37 NET0044 NET0043 10
R63 NET0133 NET0050 10
R79 NET0113 NET0040 10
R77 NET0073 NET0131 10
R14 NET0046 NET0118 10
R57 NET0098 Net-_USB4-D-_ 22
R70 NET0074 Net-_USB4-ID_ 560
R47 NET0150 Net-_USB4-D+_ 22
R3 NET0139 Net-_USB1-D+_ 22
R42 NET0130 Net-_USB1-D-_ 22
R60 NET0094 Net-_USB1-ID_ 560
DLED15 Net-_LED15-K_ Net-_D1-A_ LED_D_G
R10 0 Net-_LED15-K_ 560
C36 0 Net-_D1-A_ 100n
R40 0 Net-_LED16-K_ 560
DLED16 Net-_LED16-K_ Net-_D6-A_ LED_D_G
C105 0 Net-_D6-A_ 100n
R71 NET0111 NET0127 0
R66 NET0005 NET0140 0
R2 NET0136 NET0055 10
R28 NET0151 NET0060 10
C39 0 unconnected-_C39-Pad2_ 100n
C86 0 unconnected-_C86-Pad2_ 100n
C68 +3.3V 0 100n
R43 +3.3V Net-_U13-_WP__IO2__ 10k
R15 +3.3V Net-_U13-_HOLD__IO3__ 10k
C34 0 +3.3V 100n
C41 +3.3V 0 100n
C29 +3.3V 0 100n
C52 +3.3V 0 100n
C90 +3.3V 0 1u
C21 +3.3V 0 1u
C72 +3.3V 0 100n
C46 +3.3V 0 100n
C1 Net-_U11-C1_ 0 220n
R22 +3.3V NET0108 10k
C32 +3.3V 0 10u
R11 Net-_L3-Pad1_ Net-_U3-VCC_RF_ 10
C8 Net-_ANT2-Pad1_ Net-_U3-RF_IN_ 22p
C42 Net-_ANT2-Pad1_ 0 10n
L3 Net-_L3-Pad1_ Net-_ANT2-Pad1_ 27n
C83 +3.3V 0 100n
C95 +3.3V 0 100n
C13 Net-_U1-VO-_ Net-_U1-VO+_ 1n
C26 +3.3V 0 100n
R29 +3.3V NET0143 10k

V_3_3V +3.3V 0 DC 3.3
V_3V3 +3V3 0 DC 3.3
V_5V +5V 0 DC 5.0

.control
tran 100u 10m
set filetype=ascii
write Hades_raw.raw all
.endc

.end
