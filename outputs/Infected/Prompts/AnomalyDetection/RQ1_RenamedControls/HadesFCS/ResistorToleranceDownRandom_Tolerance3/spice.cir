.title KiCad schematic

.model LED_D_G D (Is=1p Rs=10 N=1.7)
.model LED_D_B D (Is=1p Rs=10 N=1.7)
.model LED_D_Y D (Is=1p Rs=10 N=1.7)
.model LED_D_R D (Is=1p Rs=10 N=1.7)

R56 NET0023 VIN+ 0.01
C63 +3.3V 0 100n
C97 +5V NET0097 4.7n
L3 NET0129 +5V 15u
R15 +5V NET0097 6.8k
C32 +5V 0 47u
C98 +5V 0 100u
C70 NET0129 Net-_C70-Pad2_ 100n
R17 0 NET0097 1.3k
R70 Net-_C70-Pad2_ NET0097 19.6k
C26 NET0129 NET0114 100n
DLED5 Net-_LED5-K_ +5V LED_D_G
R46 0 Net-_LED5-K_ 560
R80 NET0027 Net-_D4-A_ 10k
C36 Net-_D4-A_ 0 2.2u
C81 Net-_REG2-PVDD_ 0 2.2u
R76 NET0023 NET0144 10k
C80 NET0023 0 100u
C92 NET0023 0 47u
R66 0 Net-_LED11-K_ 240
DLED11 Net-_LED11-K_ +3.3V LED_D_G
C77 +5V 0 10u
C58 +3.3V 0 10u
C103 NET0087 0 10p
C35 Net-_C35-Pad1_ 0 10p
R33 NET0079 Net-_C35-Pad1_ 620
C73 +3V3 0 100n
C113 +3V3 0 100n
R4 +3V3 NET0123 4.7k
R85 +3V3 NET0150 4.7k
R41 +3V3 NET0072 4.7k
R94 +3V3 NET0167 4.7k
C94 +3V3 0 100n
C112 +3V3 0 100n
DLED17 Net-_LED17-K_ NET0120 LED_D_B
R72 0 Net-_LED17-K_ 100
R45 +3V3 NET0164 4.7k
R1 +3V3 NET0056 4.7k
C78 VREF+_FCC 0 100n
R5 VREF+_FCC VDDA_FCC 47
C10 VDDA_FCC 0 100n
R84 0 Net-_LED16-K_ 330
R89 0 Net-_LED6-K_ 330
DLED19 Net-_LED19-K_ NET0170 LED_D_B
R51 0 Net-_LED19-K_ 100
C100 NET0021 0 100n
R22 0 Net-_LED15-K_ 330
DLED4 Net-_LED4-K_ NET0074 LED_D_B
DLED15 Net-_LED15-K_ NET0013 LED_D_Y
R47 0 Net-_LED4-K_ 100
DLED16 Net-_LED16-K_ NET0052 LED_D_R
DLED6 Net-_LED6-K_ NET0018 LED_D_R
C24 +3V3 0 100n
C15 +3V3 0 100n
C86 +3V3 0 100n
C62 +3V3 0 100n
C90 +3V3 0 100n
C8 +3V3 0 100n
C93 +3V3 0 100n
C19 Net-_FCC2-PH0_ 0 2.2u
C107 unconnected-_C107-Pad1_ 0 2.2u
R65 Net-_SW4-C_ NET0176 10k
R74 NET0051 Net-_C66-Pad1_ 620
C66 Net-_C66-Pad1_ 0 10p
C102 NET0109 0 10p
R23 +3V3 NET0145 4.7k
R10 +3V3 NET0031 4.7k
R36 +3V3 NET0172 4.7k
R52 +3V3 NET0084 4.7k
DLED10 Net-_LED10-K_ NET0033 LED_D_Y
DLED18 Net-_LED18-K_ NET0113 LED_D_B
R25 0 Net-_LED10-K_ 330
R35 0 Net-_LED18-K_ 100
DLED2 Net-_LED2-K_ NET0085 LED_D_R
R32 0 Net-_LED2-K_ 330
DLED14 Net-_LED14-K_ NET0140 LED_D_R
R7 0 Net-_LED14-K_ 330
C110 Net-_NAVC2-PH1_ 0 2.2u
C27 Net-_NAVC2-PH0_ 0 2.2u
C79 +3V3 0 100n
C45 +3V3 0 100n
C84 VDDA_NAVC 0 100n
C17 +3V3 0 100n
C61 +3V3 0 100n
C41 +3V3 0 100n
C52 +3V3 0 100n
C109 +3V3 0 100n
C11 +3V3 0 100n
C74 +3V3 0 100n
R43 Net-_SW1-C_ NET0124 10k
C2 NET0073 0 100n
R58 Net-_SW7-C_ NET0070 10k
R3 NET0036 NET0030 10
R88 NET0099 NET0119 10
R68 NET0050 NET0141 10
R59 NET0088 NET0069 10
R64 NET0142 NET0103 10
R55 NET0078 NET0081 10
R16 NET0022 NET0166 10
R39 NET0083 NET0008 10
R49 NET0101 Net-_USB2-D-_ 22
R79 NET0122 Net-_USB2-ID_ 560
R92 NET0086 Net-_USB2-D+_ 22
R2 NET0102 Net-_USB6-D+_ 22
R38 NET0160 Net-_USB6-D-_ 22
R13 NET0026 Net-_USB6-ID_ 560
DLED21 Net-_LED21-K_ Net-_D5-A_ LED_D_G
R27 0 Net-_LED21-K_ 560
C43 0 Net-_D5-A_ 100n
R75 0 Net-_LED9-K_ 560
DLED9 Net-_LED9-K_ Net-_D2-A_ LED_D_G
C40 0 Net-_D2-A_ 100n
R78 NET0108 NET0150 0
R11 NET0077 NET0167 0
R12 NET0137 NET0011 10
R62 NET0159 NET0071 10
C75 0 unconnected-_C75-Pad2_ 100n
C96 0 unconnected-_C96-Pad2_ 100n
C56 +3.3V 0 100n
R83 +3.3V Net-_U8-_WP__IO2__ 10k
R54 +3.3V Net-_U8-_HOLD__IO3__ 10k
C101 0 +3.3V 100n
C72 +3.3V 0 100n
C9 +3.3V 0 100n
C51 +3.3V 0 100n
C71 +3.3V 0 1u
C83 +3.3V 0 1u
C106 +3.3V 0 100n
C22 +3.3V 0 100n
C34 Net-_U11-C1_ 0 220n
R37 +3.3V NET0059 10k
C30 +3.3V 0 10u
R42 Net-_L1-Pad1_ Net-_U14-VCC_RF_ 10
C111 Net-_ANT2-Pad1_ Net-_U14-RF_IN_ 22p
C59 Net-_ANT2-Pad1_ 0 10n
L1 Net-_L1-Pad1_ Net-_ANT2-Pad1_ 27n
C28 +3.3V 0 100n
C47 +3.3V 0 100n
C16 Net-_U10-VO-_ Net-_U10-VO+_ 1n
C50 +3.3V 0 100n
R34 +3.3V NET0151 10k

V_3_3V +3.3V 0 DC 3.3
V_3V3 +3V3 0 DC 3.3
V_5V +5V 0 DC 5.0

.control
tran 100u 10m
set filetype=ascii
write Hades_raw.raw all
.endc

.end
