.title KiCad schematic

.model LED_D_G D (Is=1p Rs=10 N=1.7)
.model LED_D_B D (Is=1p Rs=10 N=1.7)
.model LED_D_Y D (Is=1p Rs=10 N=1.7)
.model LED_D_R D (Is=1p Rs=10 N=1.7)

R46 NET0001 VIN+ 0.01
C102 +3.3V 0 100n
C91 +5V NET0046 4.7n
L2 NET0069 +5V 15u
R78 +5V NET0046 6.8k
C89 +5V 0 47u
C94 +5V 0 100u
C13 NET0069 Net-_C13-Pad2_ 100n
R77 0 NET0046 1.3k
R55 Net-_C13-Pad2_ NET0046 19.6k
C96 NET0069 NET0094 100n
DLED4 Net-_LED4-K_ +5V LED_D_G
R20 0 Net-_LED4-K_ 560
R43 NET0043 Net-_D8-A_ 10k
C78 Net-_D8-A_ 0 2.2u
C74 Net-_REG3-PVDD_ 0 2.2u
R90 NET0001 NET0148 10k
C48 NET0001 0 100u
C88 NET0001 0 47u
R38 0 Net-_LED21-K_ 240
DLED21 Net-_LED21-K_ +3.3V LED_D_G
C49 +5V 0 10u
C69 +3.3V 0 10u
C80 NET0082 0 10p
C9 Net-_C9-Pad1_ 0 10p
R14 NET0041 Net-_C9-Pad1_ 620
C19 +3V3 0 100n
C79 +3V3 0 100n
R63 +3V3 NET0053 4.7k
R61 +3V3 NET0021 4.7k
R87 +3V3 NET0169 4.7k
R7 +3V3 NET0052 4.7k
C112 +3V3 0 100n
C24 +3V3 0 100n
DLED15 Net-_LED15-K_ NET0033 LED_D_B
R58 0 Net-_LED15-K_ 100
R36 +3V3 NET0135 4.7k
R18 +3V3 NET0124 4.7k
C35 VREF+_FCC 0 100n
R40 VREF+_FCC VDDA_FCC 47
C21 VDDA_FCC 0 100n
R83 0 Net-_LED3-K_ 330
R54 0 Net-_LED20-K_ 330
DLED9 Net-_LED9-K_ NET0017 LED_D_B
R81 0 Net-_LED9-K_ 100
C95 NET0090 0 100n
R42 0 Net-_LED7-K_ 330
DLED2 Net-_LED2-K_ NET0163 LED_D_B
DLED7 Net-_LED7-K_ NET0031 LED_D_Y
R37 0 Net-_LED2-K_ 100
DLED3 Net-_LED3-K_ NET0111 LED_D_R
DLED20 Net-_LED20-K_ NET0160 LED_D_R
C43 +3V3 0 100n
C63 +3V3 0 100n
C38 +3V3 0 100n
C93 +3V3 0 100n
C50 +3V3 0 100n
C83 +3V3 0 100n
C45 +3V3 0 100n
C68 Net-_FCC2-PH0_ 0 2.2u
C5 unconnected-_C5-Pad1_ 0 2.2u
R5 Net-_SW3-C_ NET0059 10k
R49 NET0161 Net-_C67-Pad1_ 620
C67 Net-_C67-Pad1_ 0 10p
C113 NET0081 0 10p
R17 +3V3 NET0064 4.7k
R53 +3V3 NET0039 4.7k
R27 +3V3 NET0129 4.7k
R1 +3V3 NET0089 4.7k
DLED16 Net-_LED16-K_ NET0073 LED_D_Y
DLED22 Net-_LED22-K_ NET0029 LED_D_B
R6 0 Net-_LED16-K_ 330
R12 0 Net-_LED22-K_ 100
DLED13 Net-_LED13-K_ NET0037 LED_D_R
R33 0 Net-_LED13-K_ 330
DLED11 Net-_LED11-K_ NET0007 LED_D_R
R64 0 Net-_LED11-K_ 330
C52 Net-_NAVC2-PH1_ 0 2.2u
C62 Net-_NAVC2-PH0_ 0 2.2u
C22 +3V3 0 100n
C72 +3V3 0 100n
C47 VDDA_NAVC 0 100n
C99 +3V3 0 100n
C58 +3V3 0 100n
C60 +3V3 0 100n
C31 +3V3 0 100n
C76 +3V3 0 100n
C36 +3V3 0 100n
C106 +3V3 0 100n
R57 Net-_SW4-C_ NET0016 10k
C82 NET0143 0 100n
R70 Net-_SW7-C_ NET0126 10k
R72 NET0009 NET0011 10
R32 NET0122 NET0175 10
R60 NET0057 NET0010 10
R30 NET0005 NET0061 10
R47 NET0027 NET0132 10
R51 NET0162 NET0121 10
R31 NET0066 NET0036 10
R68 NET0068 NET0103 10
R94 NET0056 Net-_USB5-D-_ 22
R41 NET0137 Net-_USB5-ID_ 560
R67 NET0141 Net-_USB5-D+_ 22
R82 NET0093 Net-_USB3-D+_ 22
R8 NET0136 Net-_USB3-D-_ 22
R48 NET0063 Net-_USB3-ID_ 560
DLED18 Net-_LED18-K_ Net-_D7-A_ LED_D_G
R62 0 Net-_LED18-K_ 560
C70 0 Net-_D7-A_ 100n
R10 0 Net-_LED12-K_ 560
DLED12 Net-_LED12-K_ Net-_D2-A_ LED_D_G
C108 0 Net-_D2-A_ 100n
R23 NET0085 NET0021 0
R3 NET0071 NET0052 0
R19 NET0173 NET0045 10
R73 NET0107 NET0153 10
C27 0 unconnected-_C27-Pad2_ 100n
C2 0 unconnected-_C2-Pad2_ 100n
C23 +3.3V 0 100n
R29 +3.3V Net-_U5-_WP__IO2__ 10k
R2 +3.3V Net-_U5-_HOLD__IO3__ 10k
C103 0 +3.3V 100n
C84 +3.3V 0 100n
C51 +3.3V 0 100n
C41 +3.3V 0 100n
C101 +3.3V 0 1u
C44 +3.3V 0 1u
C110 +3.3V 0 100n
C12 +3.3V 0 100n
C90 Net-_U11-C1_ 0 220n
R11 +3.3V NET0105 10k
C111 +3.3V 0 10u
R52 Net-_L3-Pad1_ Net-_U2-VCC_RF_ 10
C85 Net-_ANT2-Pad1_ Net-_U2-RF_IN_ 22p
C92 Net-_ANT2-Pad1_ 0 10n
L3 Net-_L3-Pad1_ Net-_ANT2-Pad1_ 27n
C11 +3.3V 0 100n
C104 +3.3V 0 100n
C40 Net-_U19-VO-_ Net-_U19-VO+_ 1n
C3 +3.3V 0 100n
R25 +3.3V NET0032 10k

V_3_3V +3.3V 0 DC 3.3
V_3V3 +3V3 0 DC 3.3
V_5V +5V 0 DC 5.0

.control
tran 100u 10m
set filetype=ascii
write Hades_raw.raw all
.endc

.end
