.title KiCad schematic

.model LED_D_G D (Is=1p Rs=10 N=1.7)
.model LED_D_B D (Is=1p Rs=10 N=1.7)
.model LED_D_Y D (Is=1p Rs=10 N=1.7)
.model LED_D_R D (Is=1p Rs=10 N=1.7)

R55 NET0105 VIN+ 0.01
C69 +3.3V 0 100n
C78 +5V NET0007 4.7n
L2 NET0060 +5V 15u
R38 +5V NET0007 6.8k
C56 +5V 0 47u
C18 +5V 0 100u
C5 NET0060 Net-_C5-Pad2_ 100n
R15 0 NET0007 1.3k
R41 Net-_C5-Pad2_ NET0007 19.6k
C70 NET0060 NET0029 100n
DLED6 Net-_LED6-K_ +5V LED_D_G
R44 0 Net-_LED6-K_ 560
R9 NET0046 Net-_D2-A_ 10k
C92 Net-_D2-A_ 0 2.2u
C52 Net-_REG2-PVDD_ 0 2.2u
R68 NET0105 NET0108 10k
C35 NET0105 0 100u
C80 NET0105 0 47u
R78 0 Net-_LED22-K_ 240
DLED22 Net-_LED22-K_ +3.3V LED_D_G
C22 +5V 0 10u
C29 +3.3V 0 10u
C95 NET0098 0 10p
C31 Net-_C31-Pad1_ 0 10p
R13 NET0086 Net-_C31-Pad1_ 620
C73 +3V3 0 100n
C23 +3V3 0 100n
R75 +3V3 NET0003 4.7k
R26 +3V3 NET0160 4.7k
R34 +3V3 NET0147 4.7k
C27 +3V3 0 100n
R1 +3V3 NET0048 4.7k
C57 +3V3 0 100n
DLED19 Net-_LED19-K_ NET0153 LED_D_B
R61 0 Net-_LED19-K_ 100
R24 +3V3 NET0019 4.7k
R10 +3V3 NET0091 4.7k
C104 VREF+_FCC 0 100n
R6 VREF+_FCC VDDA_FCC 47
C37 VDDA_FCC 0 100n
R65 0 Net-_LED10-K_ 330
R2 0 Net-_LED11-K_ 330
DLED2 Net-_LED2-K_ NET0095 LED_D_B
R85 0 Net-_LED2-K_ 100
C19 NET0161 0 100n
R33 0 Net-_LED3-K_ 330
DLED20 Net-_LED20-K_ NET0028 LED_D_B
DLED3 Net-_LED3-K_ NET0066 LED_D_Y
R25 0 Net-_LED20-K_ 100
DLED10 Net-_LED10-K_ NET0139 LED_D_R
DLED11 Net-_LED11-K_ NET0125 LED_D_R
C28 +3V3 0 100n
C12 +3V3 0 100n
C110 +3V3 0 100n
C66 +3V3 0 100n
C1 +3V3 0 100n
C76 +3V3 0 100n
C63 +3V3 0 100n
C94 Net-_FCC2-PH0_ 0 2.2u
C11 unconnected-_C11-Pad1_ 0 2.2u
R5 Net-_SW7-C_ NET0040 10k
R36 NET0138 Net-_C54-Pad1_ 620
C54 Net-_C54-Pad1_ 0 10p
C30 NET0080 0 10p
R71 +3V3 NET0090 4.7k
R45 +3V3 NET0032 4.7k
R92 +3V3 NET0171 4.7k
R23 +3V3 NET0129 4.7k
DLED8 Net-_LED8-K_ NET0010 LED_D_Y
DLED13 Net-_LED13-K_ NET0027 LED_D_B
R20 0 Net-_LED8-K_ 330
R16 0 Net-_LED13-K_ 100
DLED4 Net-_LED4-K_ NET0145 LED_D_R
R67 0 Net-_LED4-K_ 330
DLED5 Net-_LED5-K_ NET0132 LED_D_R
R49 0 Net-_LED5-K_ 330
C105 Net-_NAVC2-PH1_ 0 2.2u
C86 Net-_NAVC2-PH0_ 0 2.2u
C85 +3V3 0 100n
C97 +3V3 0 100n
C99 VDDA_NAVC 0 100n
C112 +3V3 0 100n
C26 +3V3 0 100n
C50 +3V3 0 100n
C89 +3V3 0 100n
C68 +3V3 0 100n
C87 +3V3 0 100n
C9 +3V3 0 100n
R47 Net-_SW1-C_ NET0102 10k
C10 NET0152 0 100n
R52 Net-_SW5-C_ NET0072 10k
R76 NET0128 NET0093 10
R70 NET0041 NET0001 10
R62 NET0015 NET0087 10
R64 NET0131 NET0067 10
R31 NET0020 NET0044 10
R3 NET0175 NET0165 10
R50 NET0085 NET0071 10
R87 NET0055 NET0164 10
R57 NET0168 Net-_USB4-D-_ 22
R27 NET0033 Net-_USB4-ID_ 560
R14 NET0099 Net-_USB4-D+_ 22
R51 NET0058 Net-_USB5-D+_ 22
R77 NET0026 Net-_USB5-D-_ 22
R19 NET0170 Net-_USB5-ID_ 560
DLED12 Net-_LED12-K_ Net-_D5-A_ LED_D_G
R12 0 Net-_LED12-K_ 560
C36 0 Net-_D5-A_ 100n
R7 0 Net-_LED18-K_ 560
DLED18 Net-_LED18-K_ Net-_D6-A_ LED_D_G
C21 0 Net-_D6-A_ 100n
R59 NET0064 NET0048 0
R28 NET0103 NET0147 0
R83 NET0151 NET0053 10
R8 NET0119 NET0122 10
C67 0 unconnected-_C67-Pad2_ 100n
C61 0 unconnected-_C61-Pad2_ 100n
C64 +3.3V 0 100n
R11 +3.3V Net-_U3-_WP__IO2__ 10k
R18 +3.3V Net-_U3-_HOLD__IO3__ 10k
C42 0 +3.3V 100n
C60 +3.3V 0 100n
C13 +3.3V 0 100n
C38 +3.3V 0 100n
C7 +3.3V 0 1u
C14 +3.3V 0 1u
C6 +3.3V 0 100n
C108 +3.3V 0 100n
C103 Net-_U10-C1_ 0 220n
R32 +3.3V NET0018 10k
C41 +3.3V 0 10u
R79 Net-_L3-Pad1_ Net-_U6-VCC_RF_ 10
C62 Net-_ANT2-Pad1_ Net-_U6-RF_IN_ 22p
C51 Net-_ANT2-Pad1_ 0 10n
L3 Net-_L3-Pad1_ Net-_ANT2-Pad1_ 27n
C15 +3.3V 0 100n
C53 +3.3V 0 100n
C47 Net-_U19-VO-_ Net-_U19-VO+_ 1n
C3 +3.3V 0 100n
R94 +3.3V NET0157 10k

V_3_3V +3.3V 0 DC 3.3
V_3V3 +3V3 0 DC 3.3
V_5V +5V 0 DC 5.0

.control
tran 100u 10m
set filetype=ascii
write Hades_raw.raw all
.endc

.end
