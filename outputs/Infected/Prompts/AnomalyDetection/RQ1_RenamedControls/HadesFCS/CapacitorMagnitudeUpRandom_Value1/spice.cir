.title KiCad schematic

.model LED_D_G D (Is=1p Rs=10 N=1.7)
.model LED_D_B D (Is=1p Rs=10 N=1.7)
.model LED_D_Y D (Is=1p Rs=10 N=1.7)
.model LED_D_R D (Is=1p Rs=10 N=1.7)

R34 NET0039 VIN+ 0.01
C14 +3.3V 0 100n
C80 +5V NET0077 4.7n
L2 NET0021 +5V 15u
R27 +5V NET0077 6.8k
C28 +5V 0 47u
C30 +5V 0 100u
C63 NET0021 Net-_C63-Pad2_ 100n
R73 0 NET0077 1.3k
R89 Net-_C63-Pad2_ NET0077 19.6k
C21 NET0021 NET0121 100n
DLED17 Net-_LED17-K_ +5V LED_D_G
R58 0 Net-_LED17-K_ 560
R36 NET0018 Net-_D4-A_ 10k
C8 Net-_D4-A_ 0 2.2u
C24 Net-_REG3-PVDD_ 0 2.2u
R50 NET0039 NET0172 10k
C105 NET0039 0 100u
C81 NET0039 0 47u
R56 0 Net-_LED21-K_ 240
DLED21 Net-_LED21-K_ +3.3V LED_D_G
C39 +5V 0 10u
C74 +3.3V 0 10u
C93 NET0158 0 10p
C7 Net-_C7-Pad1_ 0 10p
R20 NET0132 Net-_C7-Pad1_ 620
C83 +3V3 0 100n
C47 +3V3 0 100n
R46 +3V3 NET0099 4.7k
R21 +3V3 NET0144 4.7k
R10 +3V3 NET0108 4.7k
R28 +3V3 NET0104 4.7k
C3 +3V3 0 100n
C29 +3V3 0 100n
DLED1 Net-_LED1-K_ NET0135 LED_D_B
R30 0 Net-_LED1-K_ 100
R69 +3V3 NET0157 4.7k
R9 +3V3 NET0024 4.7k
C65 VREF+_FCC 0 100n
R80 VREF+_FCC VDDA_FCC 47
C12 VDDA_FCC 0 100n
R91 0 Net-_LED12-K_ 330
R83 0 Net-_LED7-K_ 330
DLED6 Net-_LED6-K_ NET0059 LED_D_B
R81 0 Net-_LED6-K_ 100
C10 NET0049 0 100n
R1 0 Net-_LED13-K_ 330
DLED16 Net-_LED16-K_ NET0116 LED_D_B
DLED13 Net-_LED13-K_ NET0111 LED_D_Y
R51 0 Net-_LED16-K_ 100
DLED12 Net-_LED12-K_ NET0061 LED_D_R
DLED7 Net-_LED7-K_ NET0044 LED_D_R
C92 +3V3 0 100n
C61 +3V3 0 100n
C72 +3V3 0 100n
C112 +3V3 0 100n
C35 +3V3 0 100n
C4 +3V3 0 100n
C90 +3V3 0 100n
C38 Net-_FCC2-PH0_ 0 2.2u
C108 unconnected-_C108-Pad1_ 0 2.2u
R92 Net-_SW7-C_ NET0041 10k
R22 NET0002 Net-_C64-Pad1_ 620
C64 Net-_C64-Pad1_ 0 10p
C109 NET0162 0 10p
R6 +3V3 NET0112 4.7k
R94 +3V3 NET0100 4.7k
R33 +3V3 NET0101 4.7k
R93 +3V3 NET0071 4.7k
DLED5 Net-_LED5-K_ NET0086 LED_D_Y
DLED14 Net-_LED14-K_ NET0163 LED_D_B
R13 0 Net-_LED5-K_ 330
R84 0 Net-_LED14-K_ 100
DLED11 Net-_LED11-K_ NET0012 LED_D_R
R19 0 Net-_LED11-K_ 330
DLED2 Net-_LED2-K_ NET0045 LED_D_R
R16 0 Net-_LED2-K_ 330
C89 Net-_NAVC2-PH1_ 0 2.2u
C26 Net-_NAVC2-PH0_ 0 2.2u
C73 +3V3 0 100n
C101 +3V3 0 100n
C70 VDDA_NAVC 0 100n
C62 +3V3 0 100n
C97 +3V3 0 100n
C95 +3V3 0 100n
C68 +3V3 0 100n
C104 +3V3 0 100n
C60 +3V3 0 100n
C102 +3V3 0 100n
R52 Net-_SW4-C_ NET0046 10k
C53 NET0109 0 100n
R61 Net-_SW8-C_ NET0145 10k
R5 NET0097 NET0005 10
R88 NET0175 NET0167 10
R75 NET0013 NET0054 10
R25 NET0067 NET0065 10
R15 NET0003 NET0050 10
R86 NET0047 NET0032 10
R65 NET0102 NET0152 10
R35 NET0073 NET0119 10
R85 NET0096 Net-_USB3-D-_ 22
R72 NET0048 Net-_USB3-ID_ 560
R41 NET0056 Net-_USB3-D+_ 22
R37 NET0009 Net-_USB1-D+_ 22
R77 NET0098 Net-_USB1-D-_ 22
R60 NET0106 Net-_USB1-ID_ 560
DLED18 Net-_LED18-K_ Net-_D8-A_ LED_D_G
R49 0 Net-_LED18-K_ 560
C11 0 Net-_D8-A_ 100n
R57 0 Net-_LED10-K_ 560
DLED10 Net-_LED10-K_ Net-_D7-A_ LED_D_G
C48 0 Net-_D7-A_ 100n
R79 NET0140 NET0144 0
R82 NET0089 NET0104 0
R18 NET0156 NET0062 10
R74 NET0093 NET0052 10
C66 0 unconnected-_C66-Pad2_ 100n
C78 0 unconnected-_C78-Pad2_ 100n
C22 +3.3V 0 100n
R67 +3.3V Net-_U5-_WP__IO2__ 10k
R62 +3.3V Net-_U5-_HOLD__IO3__ 10k
C18 0 +3.3V 100n
C84 +3.3V 0 100n
C41 +3.3V 0 100n
C13 +3.3V 0 100n
C40 +3.3V 0 1u
C91 +3.3V 0 1u
C55 +3.3V 0 100n
C111 +3.3V 0 100n
C103 Net-_U19-C1_ 0 220n
R8 +3.3V NET0011 10k
C69 +3.3V 0 10u
R53 Net-_L1-Pad1_ Net-_U4-VCC_RF_ 10
C9 Net-_ANT2-Pad1_ Net-_U4-RF_IN_ 22p
C23 Net-_ANT2-Pad1_ 0 10n
L1 Net-_L1-Pad1_ Net-_ANT2-Pad1_ 27n
C77 +3.3V 0 100n
C52 +3.3V 0 100n
C54 Net-_U8-VO-_ Net-_U8-VO+_ 1n
C43 +3.3V 0 100n
R38 +3.3V NET0030 10k

V_3_3V +3.3V 0 DC 3.3
V_3V3 +3V3 0 DC 3.3
V_5V +5V 0 DC 5.0

.control
tran 100u 10m
set filetype=ascii
write Hades_raw.raw all
.endc

.end
