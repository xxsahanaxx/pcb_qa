.title KiCad schematic

.model LED_D_G D (Is=1p Rs=10 N=1.7)
.model LED_D_B D (Is=1p Rs=10 N=1.7)
.model LED_D_Y D (Is=1p Rs=10 N=1.7)
.model LED_D_R D (Is=1p Rs=10 N=1.7)

R56 NET0069 VIN+ 0.01
C107 +3.3V 0 100n
C25 +5V NET0007 4.7n
L2 NET0037 +5V 15u
R45 +5V NET0007 6.8k
C7 +5V 0 47u
C35 +5V 0 100u
C62 NET0037 Net-_C62-Pad2_ 100n
R68 0 NET0007 1.3k
R51 Net-_C62-Pad2_ NET0007 19.6k
C45 NET0037 NET0036 100n
DLED8 Net-_LED8-K_ +5V LED_D_G
R85 0 Net-_LED8-K_ 560
R52 NET0104 Net-_D5-A_ 10k
C27 Net-_D5-A_ 0 2.2u
C84 Net-_REG2-PVDD_ 0 2.2u
R27 NET0069 NET0168 10k
C60 NET0069 0 100u
C90 NET0069 0 47u
R89 0 Net-_LED11-K_ 240
DLED11 Net-_LED11-K_ +3.3V LED_D_G
C28 +5V 0 10u
C57 +3.3V 0 10u
C105 NET0002 0 10p
C34 Net-_C34-Pad1_ 0 10p
R24 NET0177 Net-_C34-Pad1_ 620
C102 +3V3 0 100n
C10 +3V3 0 100n
R32 +3V3 NET0018 4.7k
R20 +3V3 NET0175 4.7k
R61 +3V3 NET0095 4.7k
R55 +3V3 NET0129 4.7k
C86 +3V3 0 100n
C58 +3V3 0 100n
DLED7 Net-_LED7-K_ NET0076 LED_D_B
R60 0 Net-_LED7-K_ 100
R44 +3V3 NET0008 4.7k
R42 +3V3 NET0132 4.7k
C73 VREF+_FCC 0 100n
R17 VREF+_FCC VDDA_FCC 47
C8 VDDA_FCC 0 100n
R84 0 Net-_LED3-K_ 330
R10 0 Net-_LED2-K_ 330
DLED10 Net-_LED10-K_ NET0025 LED_D_B
R16 0 Net-_LED10-K_ 100
C80 NET0028 0 100n
R43 0 Net-_LED17-K_ 330
DLED21 Net-_LED21-K_ NET0126 LED_D_B
DLED17 Net-_LED17-K_ NET0050 LED_D_Y
R22 0 Net-_LED21-K_ 100
DLED3 Net-_LED3-K_ NET0056 LED_D_R
DLED2 Net-_LED2-K_ NET0089 LED_D_R
C61 +3V3 0 100n
C108 +3V3 0 100n
C113 +3V3 0 100n
C59 +3V3 0 100n
C6 +3V3 0 100n
C64 +3V3 0 100n
C103 +3V3 0 100n
C38 Net-_FCC2-PH0_ 0 2.2u
C112 unconnected-_C112-Pad1_ 0 2.2u
R88 Net-_SW1-C_ NET0107 10k
R33 NET0053 Net-_C91-Pad1_ 620
C91 Net-_C91-Pad1_ 0 10p
C15 NET0131 0 10p
R93 +3V3 NET0124 4.7k
R41 +3V3 NET0133 4.7k
R19 +3V3 NET0017 4.7k
R28 +3V3 NET0066 4.7k
DLED1 Net-_LED1-K_ NET0072 LED_D_Y
DLED15 Net-_LED15-K_ NET0109 LED_D_B
R75 0 Net-_LED1-K_ 330
R15 0 Net-_LED15-K_ 100
DLED19 Net-_LED19-K_ NET0120 LED_D_R
R2 0 Net-_LED19-K_ 330
DLED18 Net-_LED18-K_ NET0049 LED_D_R
R65 0 Net-_LED18-K_ 330
C21 Net-_NAVC2-PH1_ 0 2.2u
C4 Net-_NAVC2-PH0_ 0 2.2u
C82 +3V3 0 100n
C63 +3V3 0 100n
C53 VDDA_NAVC 0 100n
C75 +3V3 0 100n
C1 +3V3 0 100n
C17 +3V3 0 100n
C101 +3V3 0 100n
C32 +3V3 0 100n
C3 +3V3 0 100n
C66 +3V3 0 100n
R87 Net-_SW6-C_ NET0068 10k
C69 NET0130 0 100n
R31 Net-_SW8-C_ NET0101 10k
R81 NET0046 NET0140 10
R80 NET0137 NET0110 10
R78 NET0093 NET0169 10
R4 NET0087 NET0016 10
R66 NET0040 NET0039 10
R53 NET0159 NET0170 10
R92 NET0001 NET0161 10
R3 NET0075 NET0052 10
R7 NET0160 Net-_USB4-D-_ 22
R30 NET0142 Net-_USB4-ID_ 560
R94 NET0155 Net-_USB4-D+_ 22
R73 NET0136 Net-_USB6-D+_ 22
R8 NET0113 Net-_USB6-D-_ 22
R64 NET0098 Net-_USB6-ID_ 560
DLED22 Net-_LED22-K_ Net-_D3-A_ LED_D_G
R37 0 Net-_LED22-K_ 560
C22 0 Net-_D3-A_ 100n
R77 0 Net-_LED13-K_ 560
DLED13 Net-_LED13-K_ Net-_D2-A_ LED_D_G
C39 0 Net-_D2-A_ 100n
R47 NET0147 NET0175 0
R72 NET0127 NET0129 0
R82 NET0063 NET0073 10
R46 NET0031 NET0085 10
C36 0 unconnected-_C36-Pad2_ 100n
C52 0 unconnected-_C52-Pad2_ 100n
C11 +3.3V 0 100n
R11 +3.3V Net-_U16-_WP__IO2__ 10k
R69 +3.3V Net-_U16-_HOLD__IO3__ 10k
C33 0 +3.3V 100n
C81 +3.3V 0 100n
C46 +3.3V 0 100n
C30 +3.3V 0 100n
C13 +3.3V 0 1u
C56 +3.3V 0 1u
C16 +3.3V 0 100n
C111 +3.3V 0 100n
C9 Net-_U13-C1_ 0 220n
R40 +3.3V NET0043 10k
C79 +3.3V 0 10u
R70 Net-_L3-Pad1_ Net-_U14-VCC_RF_ 10
C89 Net-_ANT2-Pad1_ Net-_U14-RF_IN_ 22p
C97 Net-_ANT2-Pad1_ 0 10n
L3 Net-_L3-Pad1_ Net-_ANT2-Pad1_ 27n
C65 +3.3V 0 100n
C2 +3.3V 0 100n
C95 Net-_U2-VO-_ Net-_U2-VO+_ 1n
C93 +3.3V 0 100n
R23 +3.3V NET0118 10k

V_3_3V +3.3V 0 DC 3.3
V_3V3 +3V3 0 DC 3.3
V_5V +5V 0 DC 5.0

.control
tran 100u 10m
set filetype=ascii
write Hades_raw.raw all
.endc

.end
