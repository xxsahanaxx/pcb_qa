.title KiCad schematic

.model LED_D_G D (Is=1p Rs=10 N=1.7)
.model LED_D_B D (Is=1p Rs=10 N=1.7)
.model LED_D_Y D (Is=1p Rs=10 N=1.7)
.model LED_D_R D (Is=1p Rs=10 N=1.7)

R53 NET0139 VIN+ 0.01
C57 +3.3V 0 100n
C76 +5V NET0174 4.7n
L2 NET0081 +5V 15u
R61 +5V NET0174 6.8k
C29 +5V 0 47u
C30 +5V 0 100u
C23 NET0081 Net-_C23-Pad2_ 100n
R31 0 NET0174 1.3k
R69 Net-_C23-Pad2_ NET0174 19.6k
C52 NET0081 NET0083 100n
DLED10 Net-_LED10-K_ +5V LED_D_G
R54 0 Net-_LED10-K_ 560
R35 NET0157 Net-_D3-A_ 10k
C21 Net-_D3-A_ 0 2.2u
C72 NET0139 0 100u
C105 NET0139 0 47u
R18 NET0139 NET0011 10k
C22 Net-_REG2-PVDD_ 0 2.2u
R2 0 Net-_LED8-K_ 240
DLED8 Net-_LED8-K_ +3.3V LED_D_G
C93 +5V 0 10u
C64 +3.3V 0 10u
C53 NET0133 0 10p
C12 Net-_C12-Pad1_ 0 10p
R8 NET0099 Net-_C12-Pad1_ 620
C85 +3V3 0 100n
C63 +3V3 0 100n
R75 +3V3 NET0128 4.7k
R44 +3V3 NET0080 4.7k
R66 +3V3 NET0096 4.7k
R60 +3V3 NET0163 4.7k
C36 +3V3 0 100n
C24 +3V3 0 100n
DLED5 Net-_LED5-K_ NET0147 LED_D_B
R76 0 Net-_LED5-K_ 100
R15 +3V3 NET0123 4.7k
R91 +3V3 NET0007 4.7k
C60 VREF+_FCC 0 100n
R22 VREF+_FCC VDDA_FCC 47
C33 VDDA_FCC 0 100n
R86 0 Net-_LED19-K_ 330
R89 0 Net-_LED20-K_ 330
DLED18 Net-_LED18-K_ NET0020 LED_D_B
R71 0 Net-_LED18-K_ 100
C71 NET0032 0 100n
R10 0 Net-_LED3-K_ 330
DLED13 Net-_LED13-K_ NET0094 LED_D_B
DLED3 Net-_LED3-K_ NET0175 LED_D_Y
R20 0 Net-_LED13-K_ 100
DLED19 Net-_LED19-K_ NET0026 LED_D_R
DLED20 Net-_LED20-K_ NET0059 LED_D_R
C79 +3V3 0 100n
C9 +3V3 0 100n
C110 +3V3 0 100n
C51 +3V3 0 100n
C103 +3V3 0 100n
C32 +3V3 0 100n
C20 +3V3 0 100n
C90 Net-_FCC2-PH0_ 0 2.2u
C61 unconnected-_C61-Pad1_ 0 2.2u
R80 Net-_SW7-C_ NET0100 10k
R82 NET0050 Net-_C35-Pad1_ 620
C35 Net-_C35-Pad1_ 0 10p
C41 NET0173 0 10p
R50 +3V3 NET0101 4.7k
R38 +3V3 NET0122 4.7k
R14 +3V3 NET0046 4.7k
R41 +3V3 NET0086 4.7k
DLED14 Net-_LED14-K_ NET0130 LED_D_Y
DLED6 Net-_LED6-K_ NET0150 LED_D_B
R29 0 Net-_LED14-K_ 330
R93 0 Net-_LED6-K_ 100
DLED15 Net-_LED15-K_ NET0074 LED_D_R
R83 0 Net-_LED15-K_ 330
DLED7 Net-_LED7-K_ NET0132 LED_D_R
R48 0 Net-_LED7-K_ 330
C112 Net-_NAVC2-PH1_ 0 2.2u
C59 Net-_NAVC2-PH0_ 0 2.2u
C50 +3V3 0 100n
C4 +3V3 0 100n
C83 VDDA_NAVC 0 100n
C66 +3V3 0 100n
C47 +3V3 0 100n
C77 +3V3 0 100n
C97 +3V3 0 100n
C58 +3V3 0 100n
C107 +3V3 0 100n
C84 +3V3 0 100n
R25 Net-_SW6-C_ NET0008 10k
C42 NET0035 0 100n
R94 Net-_SW5-C_ NET0146 10k
R28 NET0145 NET0121 10
R81 NET0104 NET0029 10
R11 NET0166 NET0053 10
R58 NET0162 NET0064 10
R24 NET0111 NET0051 10
R6 NET0058 NET0038 10
R79 NET0071 NET0165 10
R46 NET0097 NET0134 10
R7 NET0055 Net-_USB3-D-_ 22
R68 NET0052 Net-_USB3-ID_ 560
R92 NET0103 Net-_USB3-D+_ 22
R45 NET0140 Net-_USB5-D+_ 22
R30 NET0047 Net-_USB5-D-_ 22
R36 NET0077 Net-_USB5-ID_ 560
C18 0 unconnected-_C18-Pad2_ 100n
C14 0 Net-_D8-A_ 100n
DLED4 Net-_LED4-K_ Net-_D8-A_ LED_D_G
R62 0 Net-_LED4-K_ 560
C1 0 unconnected-_C1-Pad2_ 100n
C39 0 Net-_D2-A_ 100n
DLED9 Net-_LED9-K_ Net-_D2-A_ LED_D_G
R42 0 Net-_LED9-K_ 560
R27 NET0027 NET0010 10
R5 NET0041 NET0078 10
R21 NET0126 NET0080 0
R32 NET0025 NET0163 0
C2 +3.3V 0 100n
R70 +3.3V Net-_U6-_WP__IO2__ 10k
R34 +3.3V Net-_U6-_HOLD__IO3__ 10k
C54 0 +3.3V 100n
C69 +3.3V 0 100n
C55 +3.3V 0 100n
C108 +3.3V 0 100n
C43 +3.3V 0 1u
C8 +3.3V 0 1u
C78 +3.3V 0 100n
C46 +3.3V 0 100n
C19 Net-_U17-C1_ 0 220n
R90 +3.3V NET0001 10k
C88 +3.3V 0 10u
R77 Net-_L3-Pad1_ Net-_U8-VCC_RF_ 10
C45 Net-_ANT2-Pad1_ Net-_U8-RF_IN_ 22p
C75 Net-_ANT2-Pad1_ 0 10n
L3 Net-_L3-Pad1_ Net-_ANT2-Pad1_ 27n
C98 +3.3V 0 100n
C82 +3.3V 0 100n
C104 Net-_U16-VO-_ Net-_U16-VO+_ 1n
C68 +3.3V 0 100n
R23 +3.3V NET0144 10k

V_3_3V +3.3V 0 DC 3.3
V_3V3 +3V3 0 DC 3.3
V_5V +5V 0 DC 5.0

.control
tran 100u 10m
set filetype=ascii
write Hades_raw.raw all
.endc

.end
