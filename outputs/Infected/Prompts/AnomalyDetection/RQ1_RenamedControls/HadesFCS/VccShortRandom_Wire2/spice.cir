.title KiCad schematic

.model LED_D_G D (Is=1p Rs=10 N=1.7)
.model LED_D_B D (Is=1p Rs=10 N=1.7)
.model LED_D_Y D (Is=1p Rs=10 N=1.7)
.model LED_D_R D (Is=1p Rs=10 N=1.7)

R5 NET0137 VIN+ 0.01
C69 +3.3V 0 100n
C53 +5V NET0042 4.7n
L3 NET0022 +5V 15u
R19 +5V NET0042 6.8k
C16 +5V 0 47u
C41 +5V 0 100u
C35 NET0022 Net-_C35-Pad2_ 100n
R44 0 NET0042 1.3k
R9 Net-_C35-Pad2_ NET0042 19.6k
C93 NET0022 NET0129 100n
DLED11 Net-_LED11-K_ +5V LED_D_G
R23 0 Net-_LED11-K_ 560
R12 NET0106 Net-_D8-A_ 10k
C50 Net-_D8-A_ 0 2.2u
C81 Net-_REG3-PVDD_ 0 2.2u
R22 NET0137 NET0073 10k
C49 NET0137 0 100u
C76 NET0137 0 47u
R80 0 Net-_LED1-K_ 240
DLED1 Net-_LED1-K_ +3.3V LED_D_G
C8 +5V 0 10u
C79 +3.3V 0 10u
C104 NET0052 0 10p
C47 Net-_C47-Pad1_ 0 10p
R20 NET0043 Net-_C47-Pad1_ 620
C54 +3V3 0 100n
C46 +3V3 0 100n
R2 +3V3 NET0003 4.7k
R71 +3V3 NET0173 4.7k
R75 +3V3 NET0167 4.7k
R92 +3V3 NET0145 4.7k
C6 +3V3 0 100n
C62 +3V3 0 100n
DLED20 Net-_LED20-K_ NET0065 LED_D_B
R94 0 Net-_LED20-K_ 100
R88 +3V3 NET0155 4.7k
R48 +3V3 NET0164 4.7k
C48 VREF+_FCC 0 100n
R32 VREF+_FCC VDDA_FCC 47
C44 VDDA_FCC 0 100n
R64 0 Net-_LED9-K_ 330
R43 0 Net-_LED8-K_ 330
DLED12 Net-_LED12-K_ NET0021 LED_D_B
R38 0 Net-_LED12-K_ 100
C68 NET0104 0 100n
R82 0 Net-_LED16-K_ 330
DLED4 Net-_LED4-K_ NET0099 LED_D_B
DLED16 Net-_LED16-K_ NET0154 LED_D_Y
R40 0 Net-_LED4-K_ 100
DLED9 Net-_LED9-K_ NET0044 LED_D_R
DLED8 Net-_LED8-K_ NET0124 LED_D_R
C2 +3V3 0 100n
C37 +3V3 0 100n
C43 +3V3 0 100n
C88 +3V3 0 100n
C23 +3V3 0 100n
C52 +3V3 0 100n
C31 +3V3 0 100n
C39 Net-_FCC2-PH0_ 0 2.2u
C78 unconnected-_C78-Pad1_ 0 2.2u
R56 Net-_SW6-C_ NET0061 10k
R70 NET0080 Net-_C85-Pad1_ 620
C85 Net-_C85-Pad1_ 0 10p
C58 NET0095 0 10p
R26 +3V3 NET0153 4.7k
R37 +3V3 NET0146 4.7k
R1 +3V3 NET0047 4.7k
R76 +3V3 NET0027 4.7k
DLED19 Net-_LED19-K_ NET0013 LED_D_Y
DLED5 Net-_LED5-K_ NET0169 LED_D_B
R90 0 Net-_LED19-K_ 330
R58 0 Net-_LED5-K_ 100
DLED2 Net-_LED2-K_ NET0138 LED_D_R
R68 0 Net-_LED2-K_ 330
DLED22 Net-_LED22-K_ NET0092 LED_D_R
R60 0 Net-_LED22-K_ 330
C42 Net-_NAVC2-PH1_ 0 2.2u
C111 Net-_NAVC2-PH0_ 0 2.2u
C51 +3V3 0 100n
C59 +3V3 0 100n
C103 VDDA_NAVC 0 100n
C25 +3V3 0 100n
C40 +3V3 0 100n
C96 +3V3 0 100n
C75 +3V3 0 100n
C45 +3V3 0 100n
C80 +3V3 0 100n
C86 +3V3 0 100n
R42 Net-_SW5-C_ NET0121 10k
C17 NET0082 0 100n
R59 Net-_SW1-C_ NET0152 10k
R57 NET0076 NET0119 10
R21 NET0056 NET0109 10
R17 NET0034 NET0116 10
R84 NET0055 NET0054 10
R7 NET0006 NET0026 10
R74 NET0077 NET0141 10
R91 NET0110 NET0158 10
R87 NET0161 NET0053 10
R25 NET0032 Net-_USB6-D-_ 22
R50 NET0101 Net-_USB6-ID_ 560
R67 NET0062 Net-_USB6-D+_ 22
R13 NET0144 Net-_USB1-D+_ 22
R33 NET0096 Net-_USB1-D-_ 22
R79 NET0083 Net-_USB1-ID_ 560
DLED14 Net-_LED14-K_ Net-_D1-A_ LED_D_G
R47 0 Net-_LED14-K_ 560
C73 0 Net-_D1-A_ 100n
R81 0 Net-_LED6-K_ 560
DLED6 Net-_LED6-K_ Net-_D4-A_ LED_D_G
C66 0 Net-_D4-A_ 100n
R4 NET0046 NET0173 0
R77 NET0068 NET0145 0
R27 NET0142 NET0035 10
R24 NET0165 NET0060 10
C60 0 unconnected-_C60-Pad2_ 100n
C87 0 unconnected-_C87-Pad2_ 100n
C18 +3.3V 0 100n
R54 +3.3V Net-_U10-_WP__IO2__ 10k
R66 +3.3V Net-_U10-_HOLD__IO3__ 10k
C10 0 +3.3V 100n
C77 +3.3V 0 100n
C14 +3.3V 0 100n
C105 +3.3V 0 100n
C34 +3.3V 0 1u
C63 +3.3V 0 1u
C19 +3.3V 0 100n
C90 +3.3V 0 100n
C21 Net-_U14-C1_ 0 220n
R16 +3.3V NET0011 10k
C95 +3.3V 0 10u
R28 Net-_L1-Pad1_ Net-_U9-VCC_RF_ 10
C28 Net-_ANT2-Pad1_ Net-_U9-RF_IN_ 22p
C61 Net-_ANT2-Pad1_ 0 10n
L1 Net-_L1-Pad1_ Net-_ANT2-Pad1_ 27n
C13 +3.3V 0 100n
C82 +3.3V 0 100n
C27 Net-_U4-VO-_ Net-_U4-VO+_ 1n
C70 +3.3V 0 100n
R46 +3.3V NET0017 10k

V_3_3V +3.3V 0 DC 3.3
V_3V3 +3V3 0 DC 3.3
V_5V +5V 0 DC 5.0

.control
tran 100u 10m
set filetype=ascii
write Hades_raw.raw all
.endc

.end
