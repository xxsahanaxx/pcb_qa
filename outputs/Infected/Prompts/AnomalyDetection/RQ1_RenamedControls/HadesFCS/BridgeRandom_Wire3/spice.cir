.title KiCad schematic

.model LED_D_G D (Is=1p Rs=10 N=1.7)
.model LED_D_B D (Is=1p Rs=10 N=1.7)
.model LED_D_Y D (Is=1p Rs=10 N=1.7)
.model LED_D_R D (Is=1p Rs=10 N=1.7)

R36 NET0083 VIN+ 0.01
C65 +3.3V 0 100n
C4 +5V NET0034 4.7n
L2 NET0018 +5V 15u
R16 +5V NET0034 6.8k
C38 +5V 0 47u
C113 +5V 0 100u
C43 NET0018 Net-_C43-Pad2_ 100n
R21 0 NET0034 1.3k
R3 Net-_C43-Pad2_ NET0034 19.6k
C93 NET0018 NET0025 100n
DLED12 Net-_LED12-K_ +5V LED_D_G
R85 0 Net-_LED12-K_ 560
R34 NET0058 Net-_D5-A_ 10k
C73 Net-_D5-A_ 0 2.2u
C80 Net-_REG3-PVDD_ 0 2.2u
R70 NET0083 NET0082 10k
C30 NET0083 0 100u
C55 NET0083 0 47u
R58 0 Net-_LED3-K_ 240
DLED3 Net-_LED3-K_ +3.3V LED_D_G
C85 +5V 0 10u
C19 +3.3V 0 10u
C92 NET0106 0 10p
C52 Net-_C52-Pad1_ 0 10p
R90 NET0176 Net-_C52-Pad1_ 620
C3 +3V3 0 100n
C102 +3V3 0 100n
R47 +3V3 NET0001 4.7k
R60 +3V3 NET0110 4.7k
R67 +3V3 NET0037 4.7k
R89 +3V3 NET0168 4.7k
C62 +3V3 0 100n
C94 +3V3 0 100n
DLED5 Net-_LED5-K_ NET0162 LED_D_B
R30 0 Net-_LED5-K_ 100
R74 +3V3 NET0113 4.7k
R32 +3V3 NET0131 4.7k
C108 VREF+_FCC 0 100n
R37 VREF+_FCC VDDA_FCC 47
C22 VDDA_FCC 0 100n
R75 0 Net-_LED1-K_ 330
R57 0 Net-_LED2-K_ 330
DLED13 Net-_LED13-K_ NET0146 LED_D_B
R77 0 Net-_LED13-K_ 100
C81 NET0101 0 100n
R92 0 Net-_LED20-K_ 330
DLED22 Net-_LED22-K_ NET0134 LED_D_B
DLED20 Net-_LED20-K_ NET0104 LED_D_Y
R61 0 Net-_LED22-K_ 100
DLED1 Net-_LED1-K_ NET0096 LED_D_R
DLED2 Net-_LED2-K_ NET0079 LED_D_R
C58 +3V3 0 100n
C6 +3V3 0 100n
C1 +3V3 0 100n
C9 +3V3 0 100n
C75 +3V3 0 100n
C98 +3V3 0 100n
C60 +3V3 0 100n
C106 Net-_FCC2-PH0_ 0 2.2u
C112 unconnected-_C112-Pad1_ 0 2.2u
R88 Net-_SW7-C_ NET0043 10k
R2 NET0128 Net-_C59-Pad1_ 620
C59 Net-_C59-Pad1_ 0 10p
C90 NET0050 0 10p
R54 +3V3 NET0144 4.7k
R25 +3V3 NET0017 4.7k
R40 +3V3 NET0011 4.7k
R80 +3V3 NET0042 4.7k
DLED19 Net-_LED19-K_ NET0154 LED_D_Y
DLED10 Net-_LED10-K_ NET0175 LED_D_B
R84 0 Net-_LED19-K_ 330
R38 0 Net-_LED10-K_ 100
DLED16 Net-_LED16-K_ NET0005 LED_D_R
R56 0 Net-_LED16-K_ 330
DLED21 Net-_LED21-K_ NET0068 LED_D_R
R15 0 Net-_LED21-K_ 330
C100 Net-_NAVC2-PH1_ 0 2.2u
C34 Net-_NAVC2-PH0_ 0 2.2u
C29 +3V3 0 100n
C39 +3V3 0 100n
C45 VDDA_NAVC 0 100n
C40 +3V3 0 100n
C57 +3V3 0 100n
C35 +3V3 0 100n
C32 +3V3 0 100n
C91 +3V3 0 100n
C50 +3V3 0 100n
C82 +3V3 0 100n
R64 Net-_SW6-C_ NET0040 10k
C54 NET0165 0 100n
R6 Net-_SW5-C_ NET0052 10k
R17 NET0053 NET0029 10
R82 NET0167 NET0172 10
R31 NET0026 NET0069 10
R52 NET0084 NET0032 10
R8 NET0155 NET0008 10
R24 NET0145 NET0048 10
R7 NET0169 NET0174 10
R93 NET0027 NET0133 10
R48 NET0085 Net-_USB4-D-_ 22
R79 NET0105 Net-_USB4-ID_ 560
R53 NET0103 Net-_USB4-D+_ 22
R5 NET0041 Net-_USB5-D+_ 22
R94 NET0157 Net-_USB5-D-_ 22
R11 NET0020 Net-_USB5-ID_ 560
C37 0 unconnected-_C37-Pad2_ 100n
C109 0 Net-_D6-A_ 100n
DLED6 Net-_LED6-K_ Net-_D6-A_ LED_D_G
R19 0 Net-_LED6-K_ 560
C56 0 unconnected-_C56-Pad2_ 100n
C24 0 Net-_D4-A_ 100n
DLED17 Net-_LED17-K_ Net-_D4-A_ LED_D_G
R45 0 Net-_LED17-K_ 560
R69 NET0016 NET0009 10
R10 NET0038 NET0002 10
R63 NET0171 NET0110 0
R71 NET0087 NET0168 0
C41 +3.3V 0 100n
R46 +3.3V Net-_U5-_WP__IO2__ 10k
R55 +3.3V Net-_U5-_HOLD__IO3__ 10k
C63 0 +3.3V 100n
C13 +3.3V 0 100n
C87 +3.3V 0 100n
C105 +3.3V 0 100n
C70 +3.3V 0 1u
C51 +3.3V 0 1u
C72 +3.3V 0 100n
C86 +3.3V 0 100n
C76 Net-_U18-C1_ 0 220n
R23 +3.3V NET0028 10k
C69 +3.3V 0 10u
R86 Net-_L3-Pad1_ Net-_U3-VCC_RF_ 10
C14 Net-_ANT2-Pad1_ Net-_U3-RF_IN_ 22p
C47 Net-_ANT2-Pad1_ 0 10n
L3 Net-_L3-Pad1_ Net-_ANT2-Pad1_ 27n
C5 +3.3V 0 100n
C88 +3.3V 0 100n
C95 Net-_U2-VO-_ Net-_U2-VO+_ 1n
C101 +3.3V 0 100n
R87 +3.3V NET0095 10k

V_3_3V +3.3V 0 DC 3.3
V_3V3 +3V3 0 DC 3.3
V_5V +5V 0 DC 5.0

.control
tran 100u 10m
set filetype=ascii
write Hades_raw.raw all
.endc

.end
