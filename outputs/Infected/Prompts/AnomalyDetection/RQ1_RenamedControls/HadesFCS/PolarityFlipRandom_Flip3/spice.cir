.title KiCad schematic

.model LED_D_G D (Is=1p Rs=10 N=1.7)
.model LED_D_B D (Is=1p Rs=10 N=1.7)
.model LED_D_Y D (Is=1p Rs=10 N=1.7)
.model LED_D_R D (Is=1p Rs=10 N=1.7)

R67 NET0042 VIN+ 0.01
C113 +3.3V 0 100n
C63 +5V NET0156 4.7n
L3 NET0119 +5V 15u
R77 +5V NET0156 6.8k
C19 +5V 0 47u
C15 +5V 0 100u
C100 NET0119 Net-_C100-Pad2_ 100n
R85 0 NET0156 1.3k
R93 Net-_C100-Pad2_ NET0156 19.6k
C78 NET0119 NET0082 100n
DLED5 Net-_LED5-K_ +5V LED_D_G
R72 0 Net-_LED5-K_ 560
R92 NET0036 Net-_D3-A_ 10k
C95 Net-_D3-A_ 0 2.2u
C39 Net-_REG2-PVDD_ 0 2.2u
R33 NET0042 NET0009 10k
C54 NET0042 0 100u
C84 NET0042 0 47u
R11 0 Net-_LED11-K_ 240
DLED11 Net-_LED11-K_ +3.3V LED_D_G
C20 +5V 0 10u
C27 +3.3V 0 10u
C81 NET0131 0 10p
C109 Net-_C109-Pad1_ 0 10p
R26 NET0077 Net-_C109-Pad1_ 620
C14 +3V3 0 100n
C104 +3V3 0 100n
R73 +3V3 NET0089 4.7k
R42 +3V3 NET0058 4.7k
R25 +3V3 NET0022 4.7k
R54 +3V3 NET0072 4.7k
C87 +3V3 0 100n
C103 +3V3 0 100n
DLED14 Net-_LED14-K_ NET0047 LED_D_B
R63 0 Net-_LED14-K_ 100
R66 +3V3 NET0152 4.7k
R59 +3V3 NET0043 4.7k
C85 VREF+_FCC 0 100n
R89 VREF+_FCC VDDA_FCC 47
C76 VDDA_FCC 0 100n
R68 0 Net-_LED18-K_ 330
R3 0 Net-_LED2-K_ 330
DLED19 Net-_LED19-K_ NET0115 LED_D_B
R82 0 Net-_LED19-K_ 100
C17 NET0066 0 100n
R79 0 Net-_LED6-K_ 330
DLED3 Net-_LED3-K_ NET0016 LED_D_B
DLED6 Net-_LED6-K_ NET0130 LED_D_Y
R84 0 Net-_LED3-K_ 100
DLED18 Net-_LED18-K_ NET0170 LED_D_R
DLED2 Net-_LED2-K_ NET0010 LED_D_R
C34 +3V3 0 100n
C99 +3V3 0 100n
C28 +3V3 0 100n
C10 +3V3 0 100n
C11 +3V3 0 100n
C13 +3V3 0 100n
C70 +3V3 0 100n
C60 Net-_FCC2-PH0_ 0 2.2u
C69 unconnected-_C69-Pad1_ 0 2.2u
R18 Net-_SW7-C_ NET0092 10k
R28 NET0109 Net-_C31-Pad1_ 620
C31 Net-_C31-Pad1_ 0 10p
C108 NET0160 0 10p
R51 +3V3 NET0004 4.7k
R6 +3V3 NET0165 4.7k
R71 +3V3 NET0171 4.7k
R65 +3V3 NET0008 4.7k
DLED17 Net-_LED17-K_ NET0011 LED_D_Y
DLED10 Net-_LED10-K_ NET0085 LED_D_B
R5 0 Net-_LED17-K_ 330
R15 0 Net-_LED10-K_ 100
DLED4 Net-_LED4-K_ NET0063 LED_D_R
R10 0 Net-_LED4-K_ 330
DLED21 Net-_LED21-K_ NET0021 LED_D_R
R64 0 Net-_LED21-K_ 330
C8 Net-_NAVC2-PH1_ 0 2.2u
C7 Net-_NAVC2-PH0_ 0 2.2u
C75 +3V3 0 100n
C29 +3V3 0 100n
C18 VDDA_NAVC 0 100n
C25 +3V3 0 100n
C3 +3V3 0 100n
C2 +3V3 0 100n
C30 +3V3 0 100n
C79 +3V3 0 100n
C66 +3V3 0 100n
C96 +3V3 0 100n
R91 Net-_SW8-C_ NET0153 10k
C46 NET0128 0 100n
R62 Net-_SW2-C_ NET0053 10k
R22 NET0067 NET0023 10
R83 NET0145 NET0127 10
R8 NET0041 NET0090 10
R58 NET0123 NET0064 10
R24 NET0133 NET0032 10
R90 NET0052 NET0148 10
R86 NET0088 NET0039 10
R81 NET0015 NET0120 10
R27 NET0135 Net-_USB3-D-_ 22
R78 NET0134 Net-_USB3-ID_ 560
R60 NET0146 Net-_USB3-D+_ 22
R48 NET0142 Net-_USB4-D+_ 22
R94 NET0126 Net-_USB4-D-_ 22
R31 NET0106 Net-_USB4-ID_ 560
DLED22 Net-_LED22-K_ Net-_D2-A_ LED_D_G
R45 0 Net-_LED22-K_ 560
C4 0 Net-_D2-A_ 100n
R7 0 Net-_LED7-K_ 560
DLED7 Net-_LED7-K_ Net-_D7-A_ LED_D_G
C53 0 Net-_D7-A_ 100n
R46 NET0078 NET0058 0
R13 NET0050 NET0072 0
R14 NET0166 NET0138 10
R53 NET0027 NET0084 10
C33 0 unconnected-_C33-Pad2_ 100n
C88 0 unconnected-_C88-Pad2_ 100n
C23 +3.3V 0 100n
R50 +3.3V Net-_U3-_WP__IO2__ 10k
R43 +3.3V Net-_U3-_HOLD__IO3__ 10k
C94 0 +3.3V 100n
C64 +3.3V 0 100n
C37 +3.3V 0 100n
C89 +3.3V 0 100n
C47 +3.3V 0 1u
C105 +3.3V 0 1u
C62 +3.3V 0 100n
C51 +3.3V 0 100n
C82 Net-_U5-C1_ 0 220n
R56 +3.3V NET0141 10k
C83 +3.3V 0 10u
R80 Net-_L1-Pad1_ Net-_U11-VCC_RF_ 10
C72 Net-_ANT2-Pad1_ Net-_U11-RF_IN_ 22p
C16 Net-_ANT2-Pad1_ 0 10n
L1 Net-_L1-Pad1_ Net-_ANT2-Pad1_ 27n
C106 +3.3V 0 100n
C92 +3.3V 0 100n
C42 Net-_U14-VO-_ Net-_U14-VO+_ 1n
C9 +3.3V 0 100n
R75 +3.3V NET0069 10k

V_3_3V +3.3V 0 DC 3.3
V_3V3 +3V3 0 DC 3.3
V_5V +5V 0 DC 5.0

.control
tran 100u 10m
set filetype=ascii
write Hades_raw.raw all
.endc

.end
