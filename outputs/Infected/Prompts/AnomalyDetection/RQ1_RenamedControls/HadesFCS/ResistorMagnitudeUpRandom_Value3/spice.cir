.title KiCad schematic

.model LED_D_G D (Is=1p Rs=10 N=1.7)
.model LED_D_B D (Is=1p Rs=10 N=1.7)
.model LED_D_Y D (Is=1p Rs=10 N=1.7)
.model LED_D_R D (Is=1p Rs=10 N=1.7)

R11 NET0008 VIN+ 0.01
C16 +3.3V 0 100n
C112 +5V NET0068 4.7n
L3 NET0066 +5V 15u
R63 +5V NET0068 6.8k
C80 +5V 0 47u
C70 +5V 0 100u
C95 NET0066 Net-_C95-Pad2_ 100n
R51 0 NET0068 1.3k
R72 Net-_C95-Pad2_ NET0068 19.6k
C81 NET0066 NET0039 100n
DLED12 Net-_LED12-K_ +5V LED_D_G
R39 0 Net-_LED12-K_ 560
R67 NET0087 Net-_D5-A_ 10k
C12 Net-_D5-A_ 0 2.2u
C4 Net-_REG2-PVDD_ 0 2.2u
R3 NET0008 NET0084 10k
C43 NET0008 0 100u
C99 NET0008 0 47u
R14 0 Net-_LED3-K_ 240
DLED3 Net-_LED3-K_ +3.3V LED_D_G
C13 +5V 0 10u
C59 +3.3V 0 10u
C49 NET0157 0 10p
C88 Net-_C88-Pad1_ 0 10p
R28 NET0041 Net-_C88-Pad1_ 620
C30 +3V3 0 100n
C42 +3V3 0 100n
R65 +3V3 NET0067 4.7k
R77 +3V3 NET0089 4.7k
R83 +3V3 NET0057 4.7k
R22 +3V3 NET0055 4.7k
C1 +3V3 0 100n
C34 +3V3 0 100n
DLED14 Net-_LED14-K_ NET0155 LED_D_B
R53 0 Net-_LED14-K_ 100
R18 +3V3 NET0044 4.7k
R66 +3V3 NET0135 4.7k
C58 VREF+_FCC 0 100n
R73 VREF+_FCC VDDA_FCC 47
C8 VDDA_FCC 0 100n
R19 0 Net-_LED7-K_ 330
R36 0 Net-_LED1-K_ 330
DLED19 Net-_LED19-K_ NET0118 LED_D_B
R92 0 Net-_LED19-K_ 100
C107 NET0025 0 100n
R61 0 Net-_LED6-K_ 330
DLED10 Net-_LED10-K_ NET0095 LED_D_B
DLED6 Net-_LED6-K_ NET0051 LED_D_Y
R42 0 Net-_LED10-K_ 100
DLED7 Net-_LED7-K_ NET0003 LED_D_R
DLED1 Net-_LED1-K_ NET0138 LED_D_R
C75 +3V3 0 100n
C32 +3V3 0 100n
C103 +3V3 0 100n
C22 +3V3 0 100n
C3 +3V3 0 100n
C52 +3V3 0 100n
C67 +3V3 0 100n
C91 Net-_FCC2-PH0_ 0 2.2u
C84 unconnected-_C84-Pad1_ 0 2.2u
R47 Net-_SW5-C_ NET0078 10k
R57 NET0023 Net-_C7-Pad1_ 620
C7 Net-_C7-Pad1_ 0 10p
C36 NET0094 0 10p
R17 +3V3 NET0139 4.7k
R12 +3V3 NET0054 4.7k
R80 +3V3 NET0035 4.7k
R23 +3V3 NET0018 4.7k
DLED15 Net-_LED15-K_ NET0096 LED_D_Y
DLED22 Net-_LED22-K_ NET0166 LED_D_B
R8 0 Net-_LED15-K_ 330
R38 0 Net-_LED22-K_ 100
DLED9 Net-_LED9-K_ NET0027 LED_D_R
R32 0 Net-_LED9-K_ 330
DLED13 Net-_LED13-K_ NET0005 LED_D_R
R70 0 Net-_LED13-K_ 330
C31 Net-_NAVC2-PH1_ 0 2.2u
C47 Net-_NAVC2-PH0_ 0 2.2u
C100 +3V3 0 100n
C93 +3V3 0 100n
C28 VDDA_NAVC 0 100n
C46 +3V3 0 100n
C78 +3V3 0 100n
C77 +3V3 0 100n
C60 +3V3 0 100n
C101 +3V3 0 100n
C64 +3V3 0 100n
C44 +3V3 0 100n
R78 Net-_SW7-C_ NET0001 10k
C35 NET0007 0 100n
R10 Net-_SW3-C_ NET0069 10k
R33 NET0037 NET0075 10
R13 NET0074 NET0100 10
R90 NET0128 NET0010 10
R76 NET0109 NET0058 10
R85 NET0076 NET0021 10
R35 NET0146 NET0152 10
R69 NET0114 NET0093 10
R81 NET0174 NET0011 10
R15 NET0013 Net-_USB6-D-_ 22
R34 NET0064 Net-_USB6-ID_ 560
R82 NET0031 Net-_USB6-D+_ 22
R41 NET0006 Net-_USB3-D+_ 22
R21 NET0104 Net-_USB3-D-_ 22
R49 NET0137 Net-_USB3-ID_ 560
DLED16 Net-_LED16-K_ Net-_D6-A_ LED_D_G
R89 0 Net-_LED16-K_ 560
C10 0 Net-_D6-A_ 100n
R58 0 Net-_LED11-K_ 560
DLED11 Net-_LED11-K_ Net-_D3-A_ LED_D_G
C96 0 Net-_D3-A_ 100n
R91 NET0002 NET0089 0
R71 NET0048 NET0055 0
R54 NET0125 NET0065 10
R62 NET0159 NET0046 10
C56 0 unconnected-_C56-Pad2_ 100n
C53 0 unconnected-_C53-Pad2_ 100n
C48 +3.3V 0 100n
R50 +3.3V Net-_U11-_WP__IO2__ 10k
R46 +3.3V Net-_U11-_HOLD__IO3__ 10k
C50 0 +3.3V 100n
C51 +3.3V 0 100n
C38 +3.3V 0 100n
C5 +3.3V 0 100n
C21 +3.3V 0 1u
C19 +3.3V 0 1u
C20 +3.3V 0 100n
C87 +3.3V 0 100n
C110 Net-_U10-C1_ 0 220n
R2 +3.3V NET0149 10k
C89 +3.3V 0 10u
R6 Net-_L1-Pad1_ Net-_U14-VCC_RF_ 10
C40 Net-_ANT2-Pad1_ Net-_U14-RF_IN_ 22p
C57 Net-_ANT2-Pad1_ 0 10n
L1 Net-_L1-Pad1_ Net-_ANT2-Pad1_ 27n
C11 +3.3V 0 100n
C33 +3.3V 0 100n
C6 Net-_U13-VO-_ Net-_U13-VO+_ 1n
C86 +3.3V 0 100n
R25 +3.3V NET0115 10k

V_3_3V +3.3V 0 DC 3.3
V_3V3 +3V3 0 DC 3.3
V_5V +5V 0 DC 5.0

.control
tran 100u 10m
set filetype=ascii
write Hades_raw.raw all
.endc

.end
