.title KiCad schematic

.model LED_D_G D (Is=1p Rs=10 N=1.7)
.model LED_D_B D (Is=1p Rs=10 N=1.7)
.model LED_D_Y D (Is=1p Rs=10 N=1.7)
.model LED_D_R D (Is=1p Rs=10 N=1.7)

R89 NET0066 VIN+ 0.01
C109 +3.3V 0 100n
C66 +5V NET0057 4.7n
L2 NET0039 +5V 15u
R41 +5V NET0057 6.8k
C58 +5V 0 47u
C9 +5V 0 100u
C57 NET0039 Net-_C57-Pad2_ 100n
R65 0 NET0057 1.3k
R27 Net-_C57-Pad2_ NET0057 19.6k
C106 NET0039 NET0062 100n
DLED21 Net-_LED21-K_ +5V LED_D_G
R21 0 Net-_LED21-K_ 560
R73 NET0132 Net-_D4-A_ 10k
C71 Net-_D4-A_ 0 2.2u
C56 Net-_REG3-PVDD_ 0 2.2u
R11 NET0066 NET0061 10k
C76 NET0066 0 100u
C90 NET0066 0 47u
R61 0 Net-_LED4-K_ 240
DLED4 Net-_LED4-K_ +3.3V LED_D_G
C20 +5V 0 10u
C49 +3.3V 0 10u
C52 NET0131 0 10p
C3 Net-_C3-Pad1_ 0 10p
R12 NET0020 Net-_C3-Pad1_ 620
C100 +3V3 0 100n
C47 +3V3 0 100n
R3 +3V3 NET0119 4.7k
R71 +3V3 NET0148 4.7k
R37 +3V3 NET0075 4.7k
R48 +3V3 NET0081 4.7k
C28 +3V3 0 100n
C55 +3V3 0 100n
DLED14 Net-_LED14-K_ NET0087 LED_D_B
R68 0 Net-_LED14-K_ 100
R54 +3V3 NET0080 4.7k
R40 +3V3 NET0143 4.7k
C37 VREF+_FCC 0 100n
R35 VREF+_FCC VDDA_FCC 47
C18 VDDA_FCC 0 100n
R93 0 Net-_LED15-K_ 330
R69 0 Net-_LED22-K_ 330
DLED17 Net-_LED17-K_ NET0162 LED_D_B
R31 0 Net-_LED17-K_ 100
C94 NET0100 0 100n
R51 0 Net-_LED18-K_ 330
DLED12 Net-_LED12-K_ NET0070 LED_D_B
DLED18 Net-_LED18-K_ NET0076 LED_D_Y
R56 0 Net-_LED12-K_ 100
DLED15 Net-_LED15-K_ NET0021 LED_D_R
DLED22 Net-_LED22-K_ NET0008 LED_D_R
C35 +3V3 0 100n
C64 +3V3 0 100n
C21 +3V3 0 100n
C29 +3V3 0 100n
C63 +3V3 0 100n
C12 +3V3 0 100n
C75 +3V3 0 100n
C80 Net-_FCC2-PH0_ 0 2.2u
C61 unconnected-_C61-Pad1_ 0 2.2u
R50 Net-_SW1-C_ NET0090 10k
R52 NET0173 Net-_C70-Pad1_ 620
C70 Net-_C70-Pad1_ 0 10p
C77 NET0015 0 10p
R76 +3V3 NET0150 4.7k
R16 +3V3 NET0101 4.7k
R87 +3V3 NET0017 4.7k
R62 +3V3 NET0009 4.7k
DLED7 Net-_LED7-K_ NET0053 LED_D_Y
DLED20 Net-_LED20-K_ NET0089 LED_D_B
R47 0 Net-_LED7-K_ 330
R14 0 Net-_LED20-K_ 100
DLED8 Net-_LED8-K_ NET0036 LED_D_R
R42 0 Net-_LED8-K_ 330
DLED6 Net-_LED6-K_ NET0044 LED_D_R
R4 0 Net-_LED6-K_ 330
C89 Net-_NAVC2-PH1_ 0 2.2u
C59 Net-_NAVC2-PH0_ 0 2.2u
C101 +3V3 0 100n
C14 +3V3 0 100n
C62 VDDA_NAVC 0 100n
C27 +3V3 0 100n
C17 +3V3 0 100n
C67 +3V3 0 100n
C15 +3V3 0 100n
C107 +3V3 0 100n
C73 +3V3 0 100n
C53 +3V3 0 100n
R58 Net-_SW5-C_ NET0011 10k
C72 NET0056 0 100n
R67 Net-_SW2-C_ NET0176 10k
R59 NET0154 NET0099 10
R80 NET0054 NET0005 10
R33 NET0069 NET0074 10
R32 NET0120 NET0018 10
R43 NET0001 NET0158 10
R66 NET0040 NET0157 10
R39 NET0026 NET0117 10
R38 NET0165 NET0083 10
R63 NET0038 Net-_USB5-D-_ 22
R18 NET0033 Net-_USB5-ID_ 560
R8 NET0128 Net-_USB5-D+_ 22
R19 NET0112 Net-_USB6-D+_ 22
R82 NET0129 Net-_USB6-D-_ 22
R70 NET0138 Net-_USB6-ID_ 560
DLED16 Net-_LED16-K_ Net-_D3-A_ LED_D_G
R85 0 Net-_LED16-K_ 560
C16 0 Net-_D3-A_ 100n
R29 0 Net-_LED10-K_ 560
DLED10 Net-_LED10-K_ Net-_D6-A_ LED_D_G
C103 0 Net-_D6-A_ 100n
R25 NET0093 NET0148 0
R88 NET0121 NET0081 0
R84 NET0065 NET0160 10
R9 NET0136 NET0133 10
C98 0 unconnected-_C98-Pad2_ 100n
C81 0 unconnected-_C81-Pad2_ 100n
C1 +3.3V 0 100n
R36 +3.3V Net-_U6-_WP__IO2__ 10k
R15 +3.3V Net-_U6-_HOLD__IO3__ 10k
C48 0 +3.3V 100n
C83 +3.3V 0 100n
C91 +3.3V 0 100n
C39 +3.3V 0 100n
C104 +3.3V 0 1u
C69 +3.3V 0 1u
C97 +3.3V 0 100n
C108 +3.3V 0 100n
C51 Net-_U19-C1_ 0 220n
R28 +3.3V NET0088 10k
C32 +3.3V 0 10u
R53 Net-_L3-Pad1_ Net-_U2-VCC_RF_ 10
C6 Net-_ANT2-Pad1_ Net-_U2-RF_IN_ 22p
C92 Net-_ANT2-Pad1_ 0 10n
L3 Net-_L3-Pad1_ Net-_ANT2-Pad1_ 27n
C30 +3.3V 0 100n
C23 +3.3V 0 100n
C105 Net-_U10-VO-_ Net-_U10-VO+_ 1n
C13 +3.3V 0 100n
R44 +3.3V NET0095 10k

V_3_3V +3.3V 0 DC 3.3
V_3V3 +3V3 0 DC 3.3
V_5V +5V 0 DC 5.0

.control
tran 100u 10m
set filetype=ascii
write Hades_raw.raw all
.endc

.end
