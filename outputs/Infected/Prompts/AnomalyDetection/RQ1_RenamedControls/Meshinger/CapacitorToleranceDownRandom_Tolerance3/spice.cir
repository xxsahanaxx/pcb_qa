.title KiCad schematic

R1 Net-_Q3-G_ +3V3 10k
C14 0 Net-_U11-K_ 1uF
C11 Net-_U1-K_ Net-_Q2-D_ 4.7uF
C7 0 Net-_U1-A_ 1uF
C1 0 NET0022 1uF
R2 Net-_Q2-S_ 0 0.47
C13 0 NET0022 0.1uF
L2 Net-_Q2-D_ NET0022 10u
C2 Net-_C2-Pad1_ 0 1uF
C19 Net-_C19-Pad1_ 0 1uF
C16 Net-_C16-Pad1_ 0 1uF
C3 Net-_C3-Pad1_ 0 1uF
C17 Net-_C17-Pad1_ 0 1uF
C10 NET0026 0 2.2u
C15 +3V3 0 10u
C6 unconnected-_C6-Pad1_ 0 0.1u

V_3V3 +3V3 0 DC 3.3

.control
tran 100u 10m
set filetype=ascii
write Meshinger_raw.raw all
.endc

.end
