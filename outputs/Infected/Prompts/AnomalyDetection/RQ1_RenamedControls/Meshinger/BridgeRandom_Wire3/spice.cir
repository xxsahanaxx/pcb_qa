.title KiCad schematic

R1 Net-_Q1-G_ +3V3 10k
C14 0 Net-_U6-K_ 1uF
C20 Net-_U10-A_ Net-_Q2-D_ 4.7uF
C4 0 Net-_U5-A_ 1uF
C5 0 NET0023 1uF
R3 Net-_Q2-S_ 0 0.47
C7 0 NET0023 0.1uF
L2 Net-_Q2-D_ NET0023 10u
C9 Net-_C9-Pad1_ 0 1uF
C1 Net-_C1-Pad1_ 0 1uF
C3 Net-_C3-Pad1_ 0 1uF
C16 Net-_C16-Pad1_ 0 1uF
C18 Net-_C18-Pad1_ 0 1uF
C2 NET0043 0 2.2u
C12 +3V3 0 10u
C8 unconnected-_C8-Pad1_ 0 0.1u

V_3V3 +3V3 0 DC 3.3

.control
tran 100u 10m
set filetype=ascii
write Meshinger_raw.raw all
.endc

.end
