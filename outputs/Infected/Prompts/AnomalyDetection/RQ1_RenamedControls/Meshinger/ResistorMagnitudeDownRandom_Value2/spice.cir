.title KiCad schematic

R1 Net-_Q1-G_ +3V3 10k
C20 0 Net-_U1-K_ 1uF
C19 Net-_U4-A_ Net-_Q2-D_ 4.7uF
C11 0 Net-_U5-A_ 1uF
C17 0 NET0015 1uF
R2 Net-_Q2-S_ 0 0.47
C14 0 NET0015 0.1uF
L3 Net-_Q2-D_ NET0015 10u
C2 Net-_C2-Pad1_ 0 1uF
C7 Net-_C7-Pad1_ 0 1uF
C3 Net-_C3-Pad1_ 0 1uF
C13 Net-_C13-Pad1_ 0 1uF
C10 Net-_C10-Pad1_ 0 1uF
C1 NET0024 0 2.2u
C12 +3V3 0 10u
C5 unconnected-_C5-Pad1_ 0 0.1u

V_3V3 +3V3 0 DC 3.3

.control
tran 100u 10m
set filetype=ascii
write Meshinger_raw.raw all
.endc

.end
