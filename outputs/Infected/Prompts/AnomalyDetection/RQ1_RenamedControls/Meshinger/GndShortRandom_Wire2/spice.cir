.title KiCad schematic

R3 Net-_Q3-G_ +3V3 10k
C11 0 Net-_U1-K_ 1uF
C17 Net-_U11-K_ Net-_Q2-D_ 4.7uF
C4 0 Net-_U11-A_ 1uF
C18 0 NET0052 1uF
R2 Net-_Q2-S_ 0 0.47
C16 0 NET0052 0.1uF
L2 Net-_Q2-D_ NET0052 10u
C10 Net-_C10-Pad1_ 0 1uF
C2 Net-_C2-Pad1_ 0 1uF
C1 Net-_C1-Pad1_ 0 1uF
C9 Net-_C9-Pad1_ 0 1uF
C20 Net-_C20-Pad1_ 0 1uF
C15 NET0043 0 2.2u
C12 +3V3 0 10u
C3 unconnected-_C3-Pad1_ 0 0.1u

V_3V3 +3V3 0 DC 3.3

.control
tran 100u 10m
set filetype=ascii
write Meshinger_raw.raw all
.endc

.end
