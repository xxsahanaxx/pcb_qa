.title KiCad schematic

R1 Net-_Q3-G_ +3V3 10k
C5 0 Net-_U8-K_ 1uF
C10 Net-_U5-K_ Net-_Q2-D_ 4.7uF
C2 0 Net-_U5-A_ 1uF
C13 0 NET0017 1uF
R2 Net-_Q2-S_ 0 0.47
C9 0 NET0017 0.1uF
L3 Net-_Q2-D_ NET0017 10u
C11 Net-_C11-Pad1_ 0 1uF
C17 Net-_C17-Pad1_ 0 1uF
C6 Net-_C6-Pad1_ 0 1uF
C18 Net-_C18-Pad1_ 0 1uF
C1 Net-_C1-Pad1_ 0 1uF
C19 NET0009 0 2.2u
C20 +3V3 0 10u
C3 unconnected-_C3-Pad1_ 0 0.1u

V_3V3 +3V3 0 DC 3.3

.control
tran 100u 10m
set filetype=ascii
write Meshinger_raw.raw all
.endc

.end
