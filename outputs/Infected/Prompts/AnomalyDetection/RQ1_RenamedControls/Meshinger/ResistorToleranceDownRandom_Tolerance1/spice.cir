.title KiCad schematic

R1 Net-_Q1-G_ +3V3 10k
C3 0 Net-_U1-K_ 1uF
C20 Net-_U2-K_ Net-_Q3-D_ 4.7uF
C8 0 Net-_U2-A_ 1uF
C1 0 NET0024 1uF
R2 Net-_Q3-S_ 0 0.47
C9 0 NET0024 0.1uF
L2 Net-_Q3-D_ NET0024 10u
C19 Net-_C19-Pad1_ 0 1uF
C12 Net-_C12-Pad1_ 0 1uF
C6 Net-_C6-Pad1_ 0 1uF
C14 Net-_C14-Pad1_ 0 1uF
C18 Net-_C18-Pad1_ 0 1uF
C5 NET0025 0 2.2u
C7 +3V3 0 10u
C17 unconnected-_C17-Pad1_ 0 0.1u

V_3V3 +3V3 0 DC 3.3

.control
tran 100u 10m
set filetype=ascii
write Meshinger_raw.raw all
.endc

.end
