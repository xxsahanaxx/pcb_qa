.title KiCad schematic

R3 Net-_Q3-G_ +3V3 10k
C7 0 Net-_U8-K_ 1uF
C13 Net-_U2-K_ Net-_Q2-D_ 4.7uF
C10 0 Net-_U2-A_ 1uF
C1 0 NET0024 1uF
R2 Net-_Q2-S_ 0 0.47
C3 0 NET0024 0.1uF
L3 Net-_Q2-D_ NET0024 10u
C12 Net-_C12-Pad1_ 0 1uF
C17 Net-_C17-Pad1_ 0 1uF
C2 Net-_C2-Pad1_ 0 1uF
C19 Net-_C19-Pad1_ 0 1uF
C8 Net-_C8-Pad1_ 0 1uF
C20 NET0025 0 2.2u
C15 +3V3 0 10u
C6 unconnected-_C6-Pad1_ 0 0.1u

V_3V3 +3V3 0 DC 3.3

.control
tran 100u 10m
set filetype=ascii
write Meshinger_raw.raw all
.endc

.end
