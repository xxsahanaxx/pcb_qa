.title KiCad schematic

R1 Net-_Q1-G_ +3V3 10k
C13 0 Net-_U5-K_ 1uF
C18 Net-_U2-K_ Net-_Q3-D_ 4.7uF
C7 0 Net-_U2-A_ 1uF
C17 0 NET0029 1uF
R2 Net-_Q3-S_ 0 0.47
C2 0 NET0029 0.1uF
L3 Net-_Q3-D_ NET0029 10u
C12 Net-_C12-Pad1_ 0 1uF
C1 Net-_C1-Pad1_ 0 1uF
C9 Net-_C9-Pad1_ 0 1uF
C6 Net-_C6-Pad1_ 0 1uF
C11 Net-_C11-Pad1_ 0 1uF
C4 NET0053 0 2.2u
C10 +3V3 0 10u
C19 unconnected-_C19-Pad1_ 0 0.1u

V_3V3 +3V3 0 DC 3.3

.control
tran 100u 10m
set filetype=ascii
write Meshinger_raw.raw all
.endc

.end
