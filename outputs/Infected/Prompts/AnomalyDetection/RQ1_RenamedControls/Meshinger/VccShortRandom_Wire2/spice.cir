.title KiCad schematic

R3 Net-_Q1-G_ +3V3 10k
C2 0 Net-_U3-K_ 1uF
C18 Net-_U10-A_ Net-_Q3-D_ 4.7uF
C13 0 Net-_U7-A_ 1uF
C11 0 NET0016 1uF
R2 Net-_Q3-S_ 0 0.47
C4 0 NET0016 0.1uF
L2 Net-_Q3-D_ NET0016 10u
C7 Net-_C7-Pad1_ 0 1uF
C17 Net-_C17-Pad1_ 0 1uF
C8 Net-_C8-Pad1_ 0 1uF
C19 Net-_C19-Pad1_ 0 1uF
C12 Net-_C12-Pad1_ 0 1uF
C15 NET0042 0 2.2u
C1 +3V3 0 10u
C10 unconnected-_C10-Pad1_ 0 0.1u

V_3V3 +3V3 0 DC 3.3

.control
tran 100u 10m
set filetype=ascii
write Meshinger_raw.raw all
.endc

.end
