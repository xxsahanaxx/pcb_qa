.title KiCad schematic

R1 Net-_Q3-G_ +3V3 10k
C2 0 Net-_U9-K_ 1uF
C1 Net-_U10-A_ Net-_Q2-D_ 4.7uF
C19 0 Net-_U4-A_ 1uF
C17 0 NET0052 1uF
R3 Net-_Q2-S_ 0 0.47
C12 0 NET0052 0.1uF
L2 Net-_Q2-D_ NET0052 10u
C20 Net-_C20-Pad1_ 0 1uF
C7 Net-_C7-Pad1_ 0 1uF
C11 Net-_C11-Pad1_ 0 1uF
C15 Net-_C15-Pad1_ 0 1uF
C10 Net-_C10-Pad1_ 0 1uF
C8 NET0032 0 2.2u
C6 +3V3 0 10u
C3 unconnected-_C3-Pad1_ 0 0.1u

V_3V3 +3V3 0 DC 3.3

.control
tran 100u 10m
set filetype=ascii
write Meshinger_raw.raw all
.endc

.end
