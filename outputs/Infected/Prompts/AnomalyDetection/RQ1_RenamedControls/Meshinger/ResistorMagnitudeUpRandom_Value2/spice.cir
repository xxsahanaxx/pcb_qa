.title KiCad schematic

R3 Net-_Q3-G_ +3V3 10k
C20 0 Net-_U4-K_ 1uF
C14 Net-_U5-K_ Net-_Q2-D_ 4.7uF
C8 0 Net-_U5-A_ 1uF
C3 0 NET0037 1uF
R2 Net-_Q2-S_ 0 0.47
C13 0 NET0037 0.1uF
L2 Net-_Q2-D_ NET0037 10u
C17 Net-_C17-Pad1_ 0 1uF
C6 Net-_C6-Pad1_ 0 1uF
C4 Net-_C4-Pad1_ 0 1uF
C12 Net-_C12-Pad1_ 0 1uF
C19 Net-_C19-Pad1_ 0 1uF
C11 NET0044 0 2.2u
C2 +3V3 0 10u
C15 unconnected-_C15-Pad1_ 0 0.1u

V_3V3 +3V3 0 DC 3.3

.control
tran 100u 10m
set filetype=ascii
write Meshinger_raw.raw all
.endc

.end
