.title KiCad schematic

R3 Net-_Q1-G_ +3V3 10k
C17 0 Net-_U9-K_ 1uF
C10 Net-_U6-K_ Net-_Q3-D_ 4.7uF
C16 0 Net-_U6-A_ 1uF
C15 0 NET0044 1uF
R2 Net-_Q3-S_ 0 0.47
C13 0 NET0044 0.1uF
L2 Net-_Q3-D_ NET0044 10u
C12 Net-_C12-Pad1_ 0 1uF
C3 Net-_C3-Pad1_ 0 1uF
C4 Net-_C4-Pad1_ 0 1uF
C8 Net-_C8-Pad1_ 0 1uF
C2 Net-_C2-Pad1_ 0 1uF
C20 NET0013 0 2.2u
C14 +3V3 0 10u
C6 unconnected-_C6-Pad1_ 0 0.1u

V_3V3 +3V3 0 DC 3.3

.control
tran 100u 10m
set filetype=ascii
write Meshinger_raw.raw all
.endc

.end
