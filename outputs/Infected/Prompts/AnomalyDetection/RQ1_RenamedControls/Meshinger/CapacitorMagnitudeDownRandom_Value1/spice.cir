.title KiCad schematic

R3 Net-_Q3-G_ +3V3 10k
C6 0 Net-_U11-K_ 1uF
C1 Net-_U4-A_ Net-_Q2-D_ 4.7uF
C14 0 Net-_U8-A_ 1uF
C3 0 NET0045 1uF
R2 Net-_Q2-S_ 0 0.47
C9 0 NET0045 0.1uF
L2 Net-_Q2-D_ NET0045 10u
C17 Net-_C17-Pad1_ 0 1uF
C7 Net-_C7-Pad1_ 0 1uF
C16 Net-_C16-Pad1_ 0 1uF
C15 Net-_C15-Pad1_ 0 1uF
C12 Net-_C12-Pad1_ 0 1uF
C5 NET0046 0 2.2u
C19 +3V3 0 10u
C10 unconnected-_C10-Pad1_ 0 0.1u

V_3V3 +3V3 0 DC 3.3

.control
tran 100u 10m
set filetype=ascii
write Meshinger_raw.raw all
.endc

.end
