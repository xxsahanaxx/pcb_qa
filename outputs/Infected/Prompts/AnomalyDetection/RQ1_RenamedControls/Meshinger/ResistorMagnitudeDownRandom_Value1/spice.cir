.title KiCad schematic

R3 Net-_Q1-G_ +3V3 10k
C14 0 Net-_U7-K_ 1uF
C9 Net-_U5-A_ Net-_Q3-D_ 4.7uF
C10 0 Net-_U9-A_ 1uF
C6 0 NET0057 1uF
R2 Net-_Q3-S_ 0 0.47
C13 0 NET0057 0.1uF
L2 Net-_Q3-D_ NET0057 10u
C7 Net-_C7-Pad1_ 0 1uF
C2 Net-_C2-Pad1_ 0 1uF
C17 Net-_C17-Pad1_ 0 1uF
C16 Net-_C16-Pad1_ 0 1uF
C8 Net-_C8-Pad1_ 0 1uF
C20 NET0007 0 2.2u
C18 +3V3 0 10u
C19 unconnected-_C19-Pad1_ 0 0.1u

V_3V3 +3V3 0 DC 3.3

.control
tran 100u 10m
set filetype=ascii
write Meshinger_raw.raw all
.endc

.end
