.title KiCad schematic

R1 Net-_Q1-G_ +3V3 10k
C6 0 Net-_U10-K_ 1uF
C18 Net-_U4-A_ Net-_Q2-D_ 4.7uF
C10 0 Net-_U5-A_ 1uF
C1 0 NET0013 1uF
R3 Net-_Q2-S_ 0 0.47
C20 0 NET0013 0.1uF
L2 Net-_Q2-D_ NET0013 10u
C5 Net-_C5-Pad1_ 0 1uF
C3 Net-_C3-Pad1_ 0 1uF
C14 Net-_C14-Pad1_ 0 1uF
C19 Net-_C19-Pad1_ 0 1uF
C15 Net-_C15-Pad1_ 0 1uF
C2 NET0036 0 2.2u
C11 +3V3 0 10u
C4 unconnected-_C4-Pad1_ 0 0.1u

V_3V3 +3V3 0 DC 3.3

.control
tran 100u 10m
set filetype=ascii
write Meshinger_raw.raw all
.endc

.end
