.title KiCad schematic

R3 Net-_Q1-G_ +3V3 10k
C20 0 Net-_U3-K_ 1uF
C12 Net-_U7-A_ Net-_Q3-D_ 4.7uF
C10 0 Net-_U8-A_ 1uF
C16 0 NET0015 1uF
R2 Net-_Q3-S_ 0 0.47
C15 0 NET0015 0.1uF
L2 Net-_Q3-D_ NET0015 10u
C13 Net-_C13-Pad1_ 0 1uF
C8 Net-_C8-Pad1_ 0 1uF
C14 Net-_C14-Pad1_ 0 1uF
C3 Net-_C3-Pad1_ 0 1uF
C17 Net-_C17-Pad1_ 0 1uF
C5 NET0009 0 2.2u
C11 +3V3 0 10u
C19 unconnected-_C19-Pad1_ 0 0.1u

V_3V3 +3V3 0 DC 3.3

.control
tran 100u 10m
set filetype=ascii
write Meshinger_raw.raw all
.endc

.end
