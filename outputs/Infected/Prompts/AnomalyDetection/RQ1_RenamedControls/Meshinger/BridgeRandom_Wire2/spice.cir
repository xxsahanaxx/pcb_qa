.title KiCad schematic

R1 Net-_Q1-G_ +3V3 10k
C18 0 Net-_U10-K_ 1uF
C2 Net-_U11-K_ Net-_Q3-D_ 4.7uF
C5 0 Net-_U11-A_ 1uF
C9 0 NET0033 1uF
R3 Net-_Q3-S_ 0 0.47
C11 0 NET0033 0.1uF
L2 Net-_Q3-D_ NET0033 10u
C3 Net-_C3-Pad1_ 0 1uF
C1 Net-_C1-Pad1_ 0 1uF
C13 Net-_C13-Pad1_ 0 1uF
C6 Net-_C6-Pad1_ 0 1uF
C10 Net-_C10-Pad1_ 0 1uF
C19 NET0009 0 2.2u
C12 +3V3 0 10u
C4 unconnected-_C4-Pad1_ 0 0.1u

V_3V3 +3V3 0 DC 3.3

.control
tran 100u 10m
set filetype=ascii
write Meshinger_raw.raw all
.endc

.end
