.title KiCad schematic

R1 Net-_Q3-G_ +3V3 10k
C13 0 Net-_U5-K_ 1uF
C20 Net-_U10-A_ Net-_Q2-D_ 4.7uF
C2 0 Net-_U9-A_ 1uF
C15 0 NET0010 1uF
R3 Net-_Q2-S_ 0 0.47
C19 0 NET0010 0.1uF
L2 Net-_Q2-D_ NET0010 10u
C1 Net-_C1-Pad1_ 0 1uF
C10 Net-_C10-Pad1_ 0 1uF
C5 Net-_C5-Pad1_ 0 1uF
C7 Net-_C7-Pad1_ 0 1uF
C9 Net-_C9-Pad1_ 0 1uF
C4 NET0056 0 2.2u
C3 +3V3 0 10u
C6 unconnected-_C6-Pad1_ 0 0.1u

V_3V3 +3V3 0 DC 3.3

.control
tran 100u 10m
set filetype=ascii
write Meshinger_raw.raw all
.endc

.end
