.title KiCad schematic

R3 Net-_Q3-G_ +3V3 10k
C17 0 Net-_U1-K_ 1uF
C16 Net-_U3-A_ Net-_Q2-D_ 4.7uF
C10 0 Net-_U7-A_ 1uF
C6 0 NET0038 1uF
R2 Net-_Q2-S_ 0 0.47
C15 0 NET0038 0.1uF
L3 Net-_Q2-D_ NET0038 10u
C2 Net-_C2-Pad1_ 0 1uF
C11 Net-_C11-Pad1_ 0 1uF
C20 Net-_C20-Pad1_ 0 1uF
C7 Net-_C7-Pad1_ 0 1uF
C4 Net-_C4-Pad1_ 0 1uF
C13 NET0022 0 2.2u
C18 +3V3 0 10u
C5 unconnected-_C5-Pad1_ 0 0.1u

V_3V3 +3V3 0 DC 3.3

.control
tran 100u 10m
set filetype=ascii
write Meshinger_raw.raw all
.endc

.end
