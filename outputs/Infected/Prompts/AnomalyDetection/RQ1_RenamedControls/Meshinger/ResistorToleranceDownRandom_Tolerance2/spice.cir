.title KiCad schematic

R1 Net-_Q1-G_ +3V3 10k
C8 0 Net-_U5-K_ 1uF
C1 Net-_U10-K_ Net-_Q2-D_ 4.7uF
C12 0 Net-_U10-A_ 1uF
C7 0 NET0020 1uF
R3 Net-_Q2-S_ 0 0.47
C19 0 NET0020 0.1uF
L2 Net-_Q2-D_ NET0020 10u
C18 Net-_C18-Pad1_ 0 1uF
C5 Net-_C5-Pad1_ 0 1uF
C10 Net-_C10-Pad1_ 0 1uF
C13 Net-_C13-Pad1_ 0 1uF
C9 Net-_C9-Pad1_ 0 1uF
C14 NET0008 0 2.2u
C17 +3V3 0 10u
C4 unconnected-_C4-Pad1_ 0 0.1u

V_3V3 +3V3 0 DC 3.3

.control
tran 100u 10m
set filetype=ascii
write Meshinger_raw.raw all
.endc

.end
