.title KiCad schematic

R3 Net-_Q1-G_ +3V3 10k
C13 0 Net-_U8-K_ 1uF
C6 Net-_U10-A_ Net-_Q2-D_ 4.7uF
C8 0 Net-_U4-A_ 1uF
C12 0 NET0056 1uF
R2 Net-_Q2-S_ 0 0.47
C16 0 NET0056 0.1uF
L2 Net-_Q2-D_ NET0056 10u
C14 Net-_C14-Pad1_ 0 1uF
C3 Net-_C3-Pad1_ 0 1uF
C17 Net-_C17-Pad1_ 0 1uF
C5 Net-_C5-Pad1_ 0 1uF
C2 Net-_C2-Pad1_ 0 1uF
C19 NET0053 0 2.2u
C9 +3V3 0 10u
C18 unconnected-_C18-Pad1_ 0 0.1u

V_3V3 +3V3 0 DC 3.3

.control
tran 100u 10m
set filetype=ascii
write Meshinger_raw.raw all
.endc

.end
