.title KiCad schematic

R3 Net-_Q1-G_ +3V3 10k
C13 0 Net-_U4-K_ 1uF
C15 Net-_U2-A_ Net-_Q2-D_ 4.7uF
C16 0 Net-_U6-A_ 1uF
C6 0 NET0033 1uF
R2 Net-_Q2-S_ 0 0.47
C7 0 NET0033 0.1uF
L2 Net-_Q2-D_ NET0033 10u
C19 Net-_C19-Pad1_ 0 1uF
C17 Net-_C17-Pad1_ 0 1uF
C18 Net-_C18-Pad1_ 0 1uF
C1 Net-_C1-Pad1_ 0 1uF
C2 Net-_C2-Pad1_ 0 1uF
C11 NET0048 0 2.2u
C14 +3V3 0 10u
C10 unconnected-_C10-Pad1_ 0 0.1u

V_3V3 +3V3 0 DC 3.3

.control
tran 100u 10m
set filetype=ascii
write Meshinger_raw.raw all
.endc

.end
