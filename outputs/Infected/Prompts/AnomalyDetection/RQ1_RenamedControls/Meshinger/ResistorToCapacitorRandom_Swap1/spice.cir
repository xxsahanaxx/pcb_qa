.title KiCad schematic

R3 Net-_Q1-G_ +3V3 10k
C16 0 Net-_U1-K_ 1uF
C14 Net-_U5-A_ Net-_Q3-D_ 4.7uF
C3 0 Net-_U7-A_ 1uF
C18 0 NET0055 1uF
R2 Net-_Q3-S_ 0 0.47
C13 0 NET0055 0.1uF
L2 Net-_Q3-D_ NET0055 10u
C4 Net-_C4-Pad1_ 0 1uF
C17 Net-_C17-Pad1_ 0 1uF
C20 Net-_C20-Pad1_ 0 1uF
C11 Net-_C11-Pad1_ 0 1uF
C19 Net-_C19-Pad1_ 0 1uF
C7 NET0046 0 2.2u
C12 +3V3 0 10u
C5 unconnected-_C5-Pad1_ 0 0.1u

V_3V3 +3V3 0 DC 3.3

.control
tran 100u 10m
set filetype=ascii
write Meshinger_raw.raw all
.endc

.end
