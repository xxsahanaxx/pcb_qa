.title KiCad schematic

R1 Net-_Q3-G_ +3V3 10k
C1 0 Net-_U6-K_ 1uF
C5 Net-_U5-A_ Net-_Q2-D_ 4.7uF
C20 0 Net-_U8-A_ 1uF
C3 0 NET0039 1uF
R2 Net-_Q2-S_ 0 0.47
C16 0 NET0039 0.1uF
L3 Net-_Q2-D_ NET0039 10u
C17 Net-_C17-Pad1_ 0 1uF
C6 Net-_C6-Pad1_ 0 1uF
C2 Net-_C2-Pad1_ 0 1uF
C19 Net-_C19-Pad1_ 0 1uF
C10 Net-_C10-Pad1_ 0 1uF
C8 NET0009 0 2.2u
C11 +3V3 0 10u
C12 unconnected-_C12-Pad1_ 0 0.1u

V_3V3 +3V3 0 DC 3.3

.control
tran 100u 10m
set filetype=ascii
write Meshinger_raw.raw all
.endc

.end
