.title KiCad schematic

R1 Net-_Q3-G_ +3V3 10k
C1 0 Net-_U4-K_ 1uF
C7 Net-_U1-K_ Net-_Q2-D_ 4.7uF
C19 0 Net-_U1-A_ 1uF
C18 0 NET0012 1uF
R2 Net-_Q2-S_ 0 0.47
C11 0 NET0012 0.1uF
L2 Net-_Q2-D_ NET0012 10u
C4 Net-_C4-Pad1_ 0 1uF
C14 Net-_C14-Pad1_ 0 1uF
C20 Net-_C20-Pad1_ 0 1uF
C16 Net-_C16-Pad1_ 0 1uF
C12 Net-_C12-Pad1_ 0 1uF
C17 NET0055 0 2.2u
C9 +3V3 0 10u
C13 unconnected-_C13-Pad1_ 0 0.1u

V_3V3 +3V3 0 DC 3.3

.control
tran 100u 10m
set filetype=ascii
write Meshinger_raw.raw all
.endc

.end
