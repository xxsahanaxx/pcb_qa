.title KiCad schematic

R1 Net-_Q1-G_ +3V3 10k
C5 0 Net-_U3-K_ 1uF
C1 Net-_U10-A_ Net-_Q2-D_ 4.7uF
C8 0 Net-_U9-A_ 1uF
C11 0 NET0006 1uF
R3 Net-_Q2-S_ 0 0.47
C16 0 NET0006 0.1uF
L2 Net-_Q2-D_ NET0006 10u
C20 Net-_C20-Pad1_ 0 1uF
C13 Net-_C13-Pad1_ 0 1uF
C2 Net-_C2-Pad1_ 0 1uF
C3 Net-_C3-Pad1_ 0 1uF
C10 Net-_C10-Pad1_ 0 1uF
C4 NET0002 0 2.2u
C19 +3V3 0 10u
C12 unconnected-_C12-Pad1_ 0 0.1u

V_3V3 +3V3 0 DC 3.3

.control
tran 100u 10m
set filetype=ascii
write Meshinger_raw.raw all
.endc

.end
