.title KiCad schematic

R1 Net-_Q3-G_ +3V3 10k
C15 0 Net-_U9-K_ 1uF
C20 Net-_U6-K_ Net-_Q2-D_ 4.7uF
C12 0 Net-_U6-A_ 1uF
C1 0 NET0052 1uF
R3 Net-_Q2-S_ 0 0.47
C4 0 NET0052 0.1uF
L2 Net-_Q2-D_ NET0052 10u
C14 Net-_C14-Pad1_ 0 1uF
C8 Net-_C8-Pad1_ 0 1uF
C16 Net-_C16-Pad1_ 0 1uF
C19 Net-_C19-Pad1_ 0 1uF
C7 Net-_C7-Pad1_ 0 1uF
C6 NET0030 0 2.2u
C10 +3V3 0 10u
C13 unconnected-_C13-Pad1_ 0 0.1u

V_3V3 +3V3 0 DC 3.3

.control
tran 100u 10m
set filetype=ascii
write Meshinger_raw.raw all
.endc

.end
