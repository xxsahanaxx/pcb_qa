.title KiCad schematic

R1 Net-_Q1-G_ +3V3 10k
C11 0 Net-_U10-K_ 1uF
C2 Net-_U5-A_ Net-_Q2-D_ 4.7uF
C19 0 Net-_U7-A_ 1uF
C17 0 NET0038 1uF
R2 Net-_Q2-S_ 0 0.47
C6 0 NET0038 0.1uF
L2 Net-_Q2-D_ NET0038 10u
C13 Net-_C13-Pad1_ 0 1uF
C1 Net-_C1-Pad1_ 0 1uF
C15 Net-_C15-Pad1_ 0 1uF
C12 Net-_C12-Pad1_ 0 1uF
C20 Net-_C20-Pad1_ 0 1uF
C4 NET0037 0 2.2u
C7 +3V3 0 10u
C3 unconnected-_C3-Pad1_ 0 0.1u

V_3V3 +3V3 0 DC 3.3

.control
tran 100u 10m
set filetype=ascii
write Meshinger_raw.raw all
.endc

.end
