.title KiCad schematic

R3 Net-_Q1-G_ +3V3 10k
C15 0 Net-_U8-K_ 1uF
C7 Net-_U1-K_ Net-_Q3-D_ 4.7uF
C14 0 Net-_U1-A_ 1uF
C13 0 NET0052 1uF
R2 Net-_Q3-S_ 0 0.47
C3 0 NET0052 0.1uF
L3 Net-_Q3-D_ NET0052 10u
C16 Net-_C16-Pad1_ 0 1uF
C19 Net-_C19-Pad1_ 0 1uF
C4 Net-_C4-Pad1_ 0 1uF
C6 Net-_C6-Pad1_ 0 1uF
C11 Net-_C11-Pad1_ 0 1uF
C9 NET0004 0 2.2u
C5 +3V3 0 10u
C12 unconnected-_C12-Pad1_ 0 0.1u

V_3V3 +3V3 0 DC 3.3

.control
tran 100u 10m
set filetype=ascii
write Meshinger_raw.raw all
.endc

.end
