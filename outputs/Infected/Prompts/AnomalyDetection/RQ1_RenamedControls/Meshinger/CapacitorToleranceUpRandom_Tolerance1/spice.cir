.title KiCad schematic

R3 Net-_Q3-G_ +3V3 10k
C13 0 Net-_U3-K_ 1uF
C20 Net-_U2-A_ Net-_Q2-D_ 4.7uF
C7 0 Net-_U4-A_ 1uF
C16 0 NET0056 1uF
R2 Net-_Q2-S_ 0 0.47
C8 0 NET0056 0.1uF
L3 Net-_Q2-D_ NET0056 10u
C6 Net-_C6-Pad1_ 0 1uF
C5 Net-_C5-Pad1_ 0 1uF
C10 Net-_C10-Pad1_ 0 1uF
C2 Net-_C2-Pad1_ 0 1uF
C19 Net-_C19-Pad1_ 0 1uF
C11 NET0020 0 2.2u
C3 +3V3 0 10u
C1 unconnected-_C1-Pad1_ 0 0.1u

V_3V3 +3V3 0 DC 3.3

.control
tran 100u 10m
set filetype=ascii
write Meshinger_raw.raw all
.endc

.end
