.title KiCad schematic

R3 Net-_Q3-G_ +3V3 10k
C20 0 Net-_U5-K_ 1uF
C9 Net-_U10-A_ Net-_Q2-D_ 4.7uF
C2 0 Net-_U6-A_ 1uF
C18 0 NET0002 1uF
R2 Net-_Q2-S_ 0 0.47
C8 0 NET0002 0.1uF
L2 Net-_Q2-D_ NET0002 10u
C3 Net-_C3-Pad1_ 0 1uF
C19 Net-_C19-Pad1_ 0 1uF
C4 Net-_C4-Pad1_ 0 1uF
C12 Net-_C12-Pad1_ 0 1uF
C15 Net-_C15-Pad1_ 0 1uF
C6 NET0015 0 2.2u
C11 +3V3 0 10u
C14 unconnected-_C14-Pad1_ 0 0.1u

V_3V3 +3V3 0 DC 3.3

.control
tran 100u 10m
set filetype=ascii
write Meshinger_raw.raw all
.endc

.end
