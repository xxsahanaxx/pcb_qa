.title KiCad schematic

R1 Net-_Q3-G_ +3V3 10k
C10 0 Net-_U9-K_ 1uF
C16 Net-_U4-K_ Net-_Q2-D_ 4.7uF
C7 0 Net-_U4-A_ 1uF
C9 0 NET0006 1uF
R3 Net-_Q2-S_ 0 0.47
C12 0 NET0006 0.1uF
L2 Net-_Q2-D_ NET0006 10u
C11 Net-_C11-Pad1_ 0 1uF
C6 Net-_C6-Pad1_ 0 1uF
C8 Net-_C8-Pad1_ 0 1uF
C3 Net-_C3-Pad1_ 0 1uF
C19 Net-_C19-Pad1_ 0 1uF
C14 NET0024 0 2.2u
C15 +3V3 0 10u
C18 unconnected-_C18-Pad1_ 0 0.1u

V_3V3 +3V3 0 DC 3.3

.control
tran 100u 10m
set filetype=ascii
write Meshinger_raw.raw all
.endc

.end
