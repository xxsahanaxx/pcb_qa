.title KiCad schematic

R3 Net-_Q3-G_ +3V3 10k
C2 0 Net-_U9-K_ 1uF
C15 Net-_U1-K_ Net-_Q2-D_ 4.7uF
C13 0 Net-_U1-A_ 1uF
C7 0 NET0051 1uF
R2 Net-_Q2-S_ 0 0.47
C4 0 NET0051 0.1uF
L2 Net-_Q2-D_ NET0051 10u
C14 Net-_C14-Pad1_ 0 1uF
C12 Net-_C12-Pad1_ 0 1uF
C9 Net-_C9-Pad1_ 0 1uF
C17 Net-_C17-Pad1_ 0 1uF
C1 Net-_C1-Pad1_ 0 1uF
C18 NET0049 0 2.2u
C8 +3V3 0 10u
C19 unconnected-_C19-Pad1_ 0 0.1u

V_3V3 +3V3 0 DC 3.3

.control
tran 100u 10m
set filetype=ascii
write Meshinger_raw.raw all
.endc

.end
