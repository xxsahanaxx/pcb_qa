.title KiCad schematic

R1 Net-_Q1-G_ +3V3 10k
C15 0 Net-_U10-K_ 1uF
C6 Net-_U2-A_ Net-_Q3-D_ 4.7uF
C5 0 Net-_U6-A_ 1uF
C8 0 NET0010 1uF
R3 Net-_Q3-S_ 0 0.47
C12 0 NET0010 0.1uF
L3 Net-_Q3-D_ NET0010 10u
C4 Net-_C4-Pad1_ 0 1uF
C3 Net-_C3-Pad1_ 0 1uF
C9 Net-_C9-Pad1_ 0 1uF
C20 Net-_C20-Pad1_ 0 1uF
C19 Net-_C19-Pad1_ 0 1uF
C7 NET0008 0 2.2u
C1 +3V3 0 10u
C10 unconnected-_C10-Pad1_ 0 0.1u

V_3V3 +3V3 0 DC 3.3

.control
tran 100u 10m
set filetype=ascii
write Meshinger_raw.raw all
.endc

.end
