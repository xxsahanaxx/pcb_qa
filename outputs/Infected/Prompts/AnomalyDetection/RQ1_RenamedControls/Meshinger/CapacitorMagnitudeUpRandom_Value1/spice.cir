.title KiCad schematic

R1 Net-_Q3-G_ +3V3 10k
C15 0 Net-_U11-K_ 1uF
C9 Net-_U6-K_ Net-_Q2-D_ 4.7uF
C8 0 Net-_U6-A_ 1uF
C10 0 NET0020 1uF
R3 Net-_Q2-S_ 0 0.47
C2 0 NET0020 0.1uF
L2 Net-_Q2-D_ NET0020 10u
C12 Net-_C12-Pad1_ 0 1uF
C6 Net-_C6-Pad1_ 0 1uF
C17 Net-_C17-Pad1_ 0 1uF
C18 Net-_C18-Pad1_ 0 1uF
C7 Net-_C7-Pad1_ 0 1uF
C19 NET0039 0 2.2u
C3 +3V3 0 10u
C20 unconnected-_C20-Pad1_ 0 0.1u

V_3V3 +3V3 0 DC 3.3

.control
tran 100u 10m
set filetype=ascii
write Meshinger_raw.raw all
.endc

.end
