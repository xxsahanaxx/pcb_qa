.title KiCad schematic

C15 VCC 0 4.7u
C18 VCC 0 4.7u
R4 VCC NET0004 10k
R3 NET0010 Net-_A3-BTN_ 1k
C22 0 NET0001 22n
C7 VCC 0 100n
C11 VCC 0 100n
C9 VCC 0 100n
C5 VCC 0 100n
C8 VCC 0 100n
C25 VCC 0 100n
R8 NET0014 VCC 10k
R5 NET0015 VCC 10k
R13 NET0003 VCC 10k
R6 NET0011 VCC 10k
R1 NET0018 VCC 10k
R10 NET0007 VCC 10k
C10 Net-_U2-C2N_ Net-_U2-C2P_ 1u
C17 Net-_U2-C1N_ Net-_U2-C1P_ 1u
C1 Net-_U2-VCOMH_ 0 4.7u
C19 Net-_U2-VCC_ 0 2.2u
R7 0 Net-_U2-IREF_ 390k
C6 VCC 0 1u
C24 VCC 0 1u

V_VCC VCC 0 DC 3.3

.control
tran 1m 10m
set filetype=ascii
write PCB_raw.raw all
.endc

.end
