.title KiCad schematic

C19 VCC 0 4.7u
C12 VCC 0 4.7u
R3 VCC NET0006 10k
R9 NET0011 Net-_A3-BTN_ 1k
C2 0 NET0013 22n
C11 VCC 0 100n
C7 VCC 0 100n
C18 VCC 0 100n
C14 VCC 0 100n
C6 VCC 0 100n
C13 VCC 0 100n
R6 NET0012 VCC 10k
R7 NET0008 VCC 10k
R8 NET0009 VCC 10k
R14 NET0005 VCC 10k
R2 NET0003 VCC 10k
R4 NET0015 VCC 10k
C10 Net-_U1-C2N_ Net-_U1-C2P_ 1u
C4 Net-_U1-C1N_ Net-_U1-C1P_ 1u
C25 Net-_U1-VCOMH_ 0 4.7u
C9 Net-_U1-VCC_ 0 2.2u
R10 0 Net-_U1-IREF_ 390k
C20 VCC 0 1u
C24 VCC 0 1u

V_VCC VCC 0 DC 3.3

.control
tran 1m 10m
set filetype=ascii
write PCB_raw.raw all
.endc

.end
