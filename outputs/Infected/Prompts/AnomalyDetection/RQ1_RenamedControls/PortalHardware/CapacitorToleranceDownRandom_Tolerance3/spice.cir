.title KiCad schematic

C14 VCC 0 4.7u
C10 VCC 0 4.7u
R14 VCC NET0005 10k
R1 NET0018 Net-_A1-BTN_ 1k
C12 0 NET0007 22n
C18 VCC 0 100n
C20 VCC 0 100n
C21 VCC 0 100n
C6 VCC 0 100n
C9 VCC 0 100n
C3 VCC 0 100n
R7 NET0010 VCC 10k
R13 NET0008 VCC 10k
R6 NET0004 VCC 10k
R5 NET0016 VCC 10k
R9 NET0017 VCC 10k
R3 NET0009 VCC 10k
C17 Net-_U3-C2N_ Net-_U3-C2P_ 1u
C16 Net-_U3-C1N_ Net-_U3-C1P_ 1u
C25 Net-_U3-VCOMH_ 0 4.7u
C22 Net-_U3-VCC_ 0 2.2u
R10 0 Net-_U3-IREF_ 390k
C1 VCC 0 1u
C7 VCC 0 1u

V_VCC VCC 0 DC 3.3

.control
tran 1m 10m
set filetype=ascii
write PCB_raw.raw all
.endc

.end
