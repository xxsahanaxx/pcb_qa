.title KiCad schematic

C6 VCC 0 4.7u
C7 VCC 0 4.7u
R5 VCC NET0009 10k
R4 NET0005 Net-_A1-BTN_ 1k
C11 0 NET0004 22n
C8 VCC 0 100n
C13 VCC 0 100n
C4 VCC 0 100n
C16 VCC 0 100n
C20 VCC 0 100n
C18 VCC 0 100n
R6 NET0019 VCC 10k
R1 NET0006 VCC 10k
R9 NET0014 VCC 10k
R13 NET0010 VCC 10k
R2 NET0001 VCC 10k
R8 NET0007 VCC 10k
C17 Net-_U2-C2N_ Net-_U2-C2P_ 1u
C3 Net-_U2-C1N_ Net-_U2-C1P_ 1u
C22 Net-_U2-VCOMH_ 0 4.7u
C1 Net-_U2-VCC_ 0 2.2u
R11 0 Net-_U2-IREF_ 390k
C24 VCC 0 1u
C25 VCC 0 1u

V_VCC VCC 0 DC 3.3

.control
tran 1m 10m
set filetype=ascii
write PCB_raw.raw all
.endc

.end
