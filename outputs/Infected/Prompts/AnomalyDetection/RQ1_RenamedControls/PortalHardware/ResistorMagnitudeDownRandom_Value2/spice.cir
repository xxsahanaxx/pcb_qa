.title KiCad schematic

C6 VCC 0 4.7u
C12 VCC 0 4.7u
R3 VCC NET0012 10k
R4 NET0007 Net-_A1-BTN_ 1k
C20 0 NET0004 22n
C2 VCC 0 100n
C19 VCC 0 100n
C15 VCC 0 100n
C5 VCC 0 100n
C13 VCC 0 100n
C17 VCC 0 100n
R13 NET0015 VCC 10k
R10 NET0001 VCC 10k
R5 NET0011 VCC 10k
R1 NET0019 VCC 10k
R8 NET0009 VCC 10k
R14 NET0018 VCC 10k
C18 Net-_U1-C2N_ Net-_U1-C2P_ 1u
C22 Net-_U1-C1N_ Net-_U1-C1P_ 1u
C16 Net-_U1-VCOMH_ 0 4.7u
C23 Net-_U1-VCC_ 0 2.2u
R2 0 Net-_U1-IREF_ 390k
C7 VCC 0 1u
C1 VCC 0 1u

V_VCC VCC 0 DC 3.3

.control
tran 1m 10m
set filetype=ascii
write PCB_raw.raw all
.endc

.end
