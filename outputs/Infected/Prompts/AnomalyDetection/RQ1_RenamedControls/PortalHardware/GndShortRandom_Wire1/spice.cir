.title KiCad schematic

C16 VCC 0 4.7u
C3 VCC 0 4.7u
R8 VCC NET0019 10k
R5 NET0006 Net-_A3-BTN_ 1k
C8 0 NET0010 22n
C17 VCC 0 100n
C10 VCC 0 100n
C22 VCC 0 100n
C18 VCC 0 100n
C11 VCC 0 100n
C15 VCC 0 100n
R10 NET0013 VCC 10k
R9 NET0018 VCC 10k
R12 NET0014 VCC 10k
R2 NET0003 VCC 10k
R13 NET0007 VCC 10k
R11 NET0001 VCC 10k
C4 Net-_U1-C2N_ Net-_U1-C2P_ 1u
C23 Net-_U1-C1N_ Net-_U1-C1P_ 1u
C1 Net-_U1-VCOMH_ 0 4.7u
C14 Net-_U1-VCC_ 0 2.2u
R4 0 Net-_U1-IREF_ 390k
C7 VCC 0 1u
C19 VCC 0 1u

V_VCC VCC 0 DC 3.3

.control
tran 1m 10m
set filetype=ascii
write PCB_raw.raw all
.endc

.end
