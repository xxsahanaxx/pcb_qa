.title KiCad schematic

C21 VCC 0 4.7u
C15 VCC 0 4.7u
R8 VCC NET0015 10k
R13 NET0001 Net-_A1-BTN_ 1k
C25 0 NET0003 22n
C24 VCC 0 100n
C1 VCC 0 100n
C18 VCC 0 100n
C14 VCC 0 100n
C23 VCC 0 100n
C5 VCC 0 100n
R3 NET0019 VCC 10k
R14 NET0006 VCC 10k
R4 NET0004 VCC 10k
R2 NET0012 VCC 10k
R12 NET0014 VCC 10k
R5 NET0007 VCC 10k
C11 Net-_U3-C2N_ Net-_U3-C2P_ 1u
C3 Net-_U3-C1N_ Net-_U3-C1P_ 1u
C9 Net-_U3-VCOMH_ 0 4.7u
C10 Net-_U3-VCC_ 0 2.2u
R1 0 Net-_U3-IREF_ 390k
C16 VCC 0 1u
C12 VCC 0 1u

V_VCC VCC 0 DC 3.3

.control
tran 1m 10m
set filetype=ascii
write PCB_raw.raw all
.endc

.end
