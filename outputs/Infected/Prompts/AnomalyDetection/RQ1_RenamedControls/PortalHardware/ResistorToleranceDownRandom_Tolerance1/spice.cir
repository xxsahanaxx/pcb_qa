.title KiCad schematic

C7 VCC 0 4.7u
C17 VCC 0 4.7u
R1 VCC NET0001 10k
R10 NET0016 Net-_A1-BTN_ 1k
C24 0 NET0002 22n
C21 VCC 0 100n
C13 VCC 0 100n
C18 VCC 0 100n
C9 VCC 0 100n
C16 VCC 0 100n
C23 VCC 0 100n
R4 NET0011 VCC 10k
R9 NET0014 VCC 10k
R7 NET0005 VCC 10k
R3 NET0003 VCC 10k
R8 NET0017 VCC 10k
R13 NET0004 VCC 10k
C19 Net-_U2-C2N_ Net-_U2-C2P_ 1u
C5 Net-_U2-C1N_ Net-_U2-C1P_ 1u
C2 Net-_U2-VCOMH_ 0 4.7u
C6 Net-_U2-VCC_ 0 2.2u
R12 0 Net-_U2-IREF_ 390k
C3 VCC 0 1u
C12 VCC 0 1u

V_VCC VCC 0 DC 3.3

.control
tran 1m 10m
set filetype=ascii
write PCB_raw.raw all
.endc

.end
