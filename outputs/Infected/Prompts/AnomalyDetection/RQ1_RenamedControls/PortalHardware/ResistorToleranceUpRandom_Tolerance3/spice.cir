.title KiCad schematic

C7 VCC 0 4.7u
C12 VCC 0 4.7u
R14 VCC NET0018 10k
R2 NET0004 Net-_A3-BTN_ 1k
C5 0 NET0010 22n
C8 VCC 0 100n
C18 VCC 0 100n
C23 VCC 0 100n
C11 VCC 0 100n
C21 VCC 0 100n
C4 VCC 0 100n
R3 NET0003 VCC 10k
R12 NET0017 VCC 10k
R5 NET0008 VCC 10k
R11 NET0005 VCC 10k
R10 NET0001 VCC 10k
R6 NET0015 VCC 10k
C22 Net-_U1-C2N_ Net-_U1-C2P_ 1u
C14 Net-_U1-C1N_ Net-_U1-C1P_ 1u
C1 Net-_U1-VCOMH_ 0 4.7u
C3 Net-_U1-VCC_ 0 2.2u
R1 0 Net-_U1-IREF_ 390k
C9 VCC 0 1u
C15 VCC 0 1u

V_VCC VCC 0 DC 3.3

.control
tran 1m 10m
set filetype=ascii
write PCB_raw.raw all
.endc

.end
