.title KiCad schematic

C12 VCC 0 4.7u
C15 VCC 0 4.7u
R6 VCC NET0002 10k
R14 NET0001 Net-_A3-BTN_ 1k
C4 0 NET0003 22n
C23 VCC 0 100n
C17 VCC 0 100n
C19 VCC 0 100n
C13 VCC 0 100n
C1 VCC 0 100n
C2 VCC 0 100n
R10 NET0018 VCC 10k
R4 NET0005 VCC 10k
R12 NET0017 VCC 10k
R13 NET0006 VCC 10k
R2 NET0008 VCC 10k
R5 NET0019 VCC 10k
C20 Net-_U3-C2N_ Net-_U3-C2P_ 1u
C8 Net-_U3-C1N_ Net-_U3-C1P_ 1u
C21 Net-_U3-VCOMH_ 0 4.7u
C11 Net-_U3-VCC_ 0 2.2u
R7 0 Net-_U3-IREF_ 390k
C5 VCC 0 1u
C18 VCC 0 1u

V_VCC VCC 0 DC 3.3

.control
tran 1m 10m
set filetype=ascii
write PCB_raw.raw all
.endc

.end
