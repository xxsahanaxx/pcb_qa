.title KiCad schematic

C21 VCC 0 4.7u
C13 VCC 0 4.7u
R8 VCC NET0014 10k
R6 NET0008 Net-_A1-BTN_ 1k
C4 0 NET0019 22n
C7 VCC 0 100n
C19 VCC 0 100n
C16 VCC 0 100n
C3 VCC 0 100n
C25 VCC 0 100n
C11 VCC 0 100n
R5 NET0011 VCC 10k
R7 NET0004 VCC 10k
R11 NET0017 VCC 10k
R1 NET0007 VCC 10k
R10 NET0015 VCC 10k
R12 NET0006 VCC 10k
C10 Net-_U2-C2N_ Net-_U2-C2P_ 1u
C9 Net-_U2-C1N_ Net-_U2-C1P_ 1u
C6 Net-_U2-VCOMH_ 0 4.7u
C8 Net-_U2-VCC_ 0 2.2u
R3 0 Net-_U2-IREF_ 390k
C23 VCC 0 1u
C12 VCC 0 1u

V_VCC VCC 0 DC 3.3

.control
tran 1m 10m
set filetype=ascii
write PCB_raw.raw all
.endc

.end
