.title KiCad schematic

C3 VCC 0 4.7u
C10 VCC 0 4.7u
R3 VCC NET0012 10k
R1 NET0009 Net-_A3-BTN_ 1k
C6 0 NET0013 22n
C17 VCC 0 100n
C18 VCC 0 100n
C22 VCC 0 100n
C20 VCC 0 100n
C25 VCC 0 100n
C21 VCC 0 100n
R7 NET0001 VCC 10k
R6 NET0017 VCC 10k
R12 NET0006 VCC 10k
R5 NET0018 VCC 10k
R8 NET0015 VCC 10k
R13 NET0019 VCC 10k
C23 Net-_U1-C2N_ Net-_U1-C2P_ 1u
C13 Net-_U1-C1N_ Net-_U1-C1P_ 1u
C14 Net-_U1-VCOMH_ 0 4.7u
C8 Net-_U1-VCC_ 0 2.2u
R2 0 Net-_U1-IREF_ 390k
C7 VCC 0 1u
C4 VCC 0 1u

V_VCC VCC 0 DC 3.3

.control
tran 1m 10m
set filetype=ascii
write PCB_raw.raw all
.endc

.end
