.title KiCad schematic

C15 VCC 0 4.7u
C8 VCC 0 4.7u
R13 VCC NET0007 10k
R5 NET0003 Net-_A3-BTN_ 1k
C21 0 NET0014 22n
C3 VCC 0 100n
C20 VCC 0 100n
C12 VCC 0 100n
C23 VCC 0 100n
C19 VCC 0 100n
C7 VCC 0 100n
R2 NET0004 VCC 10k
R8 NET0001 VCC 10k
R1 NET0002 VCC 10k
R6 NET0016 VCC 10k
R9 NET0011 VCC 10k
R4 NET0013 VCC 10k
C14 Net-_U3-C2N_ Net-_U3-C2P_ 1u
C5 Net-_U3-C1N_ Net-_U3-C1P_ 1u
C13 Net-_U3-VCOMH_ 0 4.7u
C24 Net-_U3-VCC_ 0 2.2u
R7 0 Net-_U3-IREF_ 390k
C16 VCC 0 1u
C17 VCC 0 1u

V_VCC VCC 0 DC 3.3

.control
tran 1m 10m
set filetype=ascii
write PCB_raw.raw all
.endc

.end
