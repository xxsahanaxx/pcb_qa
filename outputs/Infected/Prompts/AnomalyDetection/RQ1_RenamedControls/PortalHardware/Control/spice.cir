.title KiCad schematic

C17 VCC 0 4.7u
C5 VCC 0 4.7u
R12 VCC NET0001 10k
R7 NET0017 Net-_A1-BTN_ 1k
C16 0 NET0019 22n
C23 VCC 0 100n
C18 VCC 0 100n
C13 VCC 0 100n
C15 VCC 0 100n
C6 VCC 0 100n
C21 VCC 0 100n
R11 NET0011 VCC 10k
R5 NET0004 VCC 10k
R9 NET0015 VCC 10k
R14 NET0016 VCC 10k
R10 NET0007 VCC 10k
R2 NET0002 VCC 10k
C14 Net-_U3-C2N_ Net-_U3-C2P_ 1u
C19 Net-_U3-C1N_ Net-_U3-C1P_ 1u
C2 Net-_U3-VCOMH_ 0 4.7u
C1 Net-_U3-VCC_ 0 2.2u
R3 0 Net-_U3-IREF_ 390k
C4 VCC 0 1u
C24 VCC 0 1u

V_VCC VCC 0 DC 3.3

.control
tran 1m 10m
set filetype=ascii
write PCB_raw.raw all
.endc

.end
