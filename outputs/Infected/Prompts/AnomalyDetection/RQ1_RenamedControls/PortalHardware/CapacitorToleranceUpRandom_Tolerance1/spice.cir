.title KiCad schematic

C14 VCC 0 4.7u
C15 VCC 0 4.7u
R2 VCC NET0004 10k
R9 NET0018 Net-_A1-BTN_ 1k
C9 0 NET0016 22n
C8 VCC 0 100n
C3 VCC 0 100n
C19 VCC 0 100n
C10 VCC 0 100n
C6 VCC 0 100n
C20 VCC 0 100n
R5 NET0019 VCC 10k
R14 NET0014 VCC 10k
R6 NET0003 VCC 10k
R11 NET0006 VCC 10k
R3 NET0008 VCC 10k
R1 NET0010 VCC 10k
C18 Net-_U3-C2N_ Net-_U3-C2P_ 1u
C11 Net-_U3-C1N_ Net-_U3-C1P_ 1u
C23 Net-_U3-VCOMH_ 0 4.7u
C4 Net-_U3-VCC_ 0 2.2u
R4 0 Net-_U3-IREF_ 390k
C22 VCC 0 1u
C12 VCC 0 1u

V_VCC VCC 0 DC 3.3

.control
tran 1m 10m
set filetype=ascii
write PCB_raw.raw all
.endc

.end
