.title KiCad schematic

C11 VCC 0 4.7u
C13 VCC 0 4.7u
R7 VCC NET0001 10k
R5 NET0012 Net-_A1-BTN_ 1k
C12 0 NET0017 22n
C7 VCC 0 100n
C5 VCC 0 100n
C1 VCC 0 100n
C3 VCC 0 100n
C19 VCC 0 100n
C14 VCC 0 100n
R13 NET0010 VCC 10k
R3 NET0019 VCC 10k
R6 NET0005 VCC 10k
R14 NET0011 VCC 10k
R1 NET0007 VCC 10k
R12 NET0003 VCC 10k
C4 Net-_U1-C2N_ Net-_U1-C2P_ 1u
C2 Net-_U1-C1N_ Net-_U1-C1P_ 1u
C24 Net-_U1-VCOMH_ 0 4.7u
C10 Net-_U1-VCC_ 0 2.2u
R4 0 Net-_U1-IREF_ 390k
C8 VCC 0 1u
C25 VCC 0 1u

V_VCC VCC 0 DC 3.3

.control
tran 1m 10m
set filetype=ascii
write PCB_raw.raw all
.endc

.end
