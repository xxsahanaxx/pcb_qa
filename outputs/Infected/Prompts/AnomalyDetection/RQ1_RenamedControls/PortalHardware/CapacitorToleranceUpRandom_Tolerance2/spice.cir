.title KiCad schematic

C23 VCC 0 4.7u
C16 VCC 0 4.7u
R4 VCC NET0005 10k
R6 NET0011 Net-_A1-BTN_ 1k
C17 0 NET0012 22n
C19 VCC 0 100n
C9 VCC 0 100n
C18 VCC 0 100n
C3 VCC 0 100n
C14 VCC 0 100n
C12 VCC 0 100n
R11 NET0007 VCC 10k
R13 NET0016 VCC 10k
R9 NET0018 VCC 10k
R14 NET0017 VCC 10k
R7 NET0013 VCC 10k
R1 NET0010 VCC 10k
C21 Net-_U3-C2N_ Net-_U3-C2P_ 1u
C15 Net-_U3-C1N_ Net-_U3-C1P_ 1u
C13 Net-_U3-VCOMH_ 0 4.7u
C25 Net-_U3-VCC_ 0 2.2u
R8 0 Net-_U3-IREF_ 390k
C2 VCC 0 1u
C24 VCC 0 1u

V_VCC VCC 0 DC 3.3

.control
tran 1m 10m
set filetype=ascii
write PCB_raw.raw all
.endc

.end
