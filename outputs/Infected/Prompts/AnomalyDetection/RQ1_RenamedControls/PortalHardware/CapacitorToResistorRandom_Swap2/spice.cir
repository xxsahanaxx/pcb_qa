.title KiCad schematic

C13 VCC 0 4.7u
C3 VCC 0 4.7u
R9 VCC NET0009 10k
R12 NET0014 Net-_A3-BTN_ 1k
C8 0 NET0013 22n
C9 VCC 0 100n
C14 VCC 0 100n
C1 VCC 0 100n
C16 VCC 0 100n
C20 VCC 0 100n
C18 VCC 0 100n
R7 NET0017 VCC 10k
R6 NET0008 VCC 10k
R1 NET0001 VCC 10k
R3 NET0018 VCC 10k
R13 NET0002 VCC 10k
R5 NET0019 VCC 10k
C4 Net-_U3-C2N_ Net-_U3-C2P_ 1u
C6 Net-_U3-C1N_ Net-_U3-C1P_ 1u
C22 Net-_U3-VCOMH_ 0 4.7u
C21 Net-_U3-VCC_ 0 2.2u
R2 0 Net-_U3-IREF_ 390k
C24 VCC 0 1u
C15 VCC 0 1u

V_VCC VCC 0 DC 3.3

.control
tran 1m 10m
set filetype=ascii
write PCB_raw.raw all
.endc

.end
