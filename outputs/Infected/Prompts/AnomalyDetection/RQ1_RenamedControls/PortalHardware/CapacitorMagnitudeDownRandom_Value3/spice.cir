.title KiCad schematic

C2 VCC 0 4.7u
C10 VCC 0 4.7u
R7 VCC NET0001 10k
R6 NET0012 Net-_A3-BTN_ 1k
C16 0 NET0013 22n
C9 VCC 0 100n
C12 VCC 0 100n
C17 VCC 0 100n
C13 VCC 0 100n
C6 VCC 0 100n
C20 VCC 0 100n
R3 NET0006 VCC 10k
R4 NET0003 VCC 10k
R5 NET0014 VCC 10k
R8 NET0010 VCC 10k
R13 NET0019 VCC 10k
R11 NET0004 VCC 10k
C5 Net-_U3-C2N_ Net-_U3-C2P_ 1u
C24 Net-_U3-C1N_ Net-_U3-C1P_ 1u
C22 Net-_U3-VCOMH_ 0 4.7u
C18 Net-_U3-VCC_ 0 2.2u
R10 0 Net-_U3-IREF_ 390k
C21 VCC 0 1u
C3 VCC 0 1u

V_VCC VCC 0 DC 3.3

.control
tran 1m 10m
set filetype=ascii
write PCB_raw.raw all
.endc

.end
