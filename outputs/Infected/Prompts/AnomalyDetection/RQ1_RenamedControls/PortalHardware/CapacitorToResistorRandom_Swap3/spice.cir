.title KiCad schematic

C7 VCC 0 4.7u
C17 VCC 0 4.7u
R14 VCC NET0009 10k
R10 NET0017 Net-_A1-BTN_ 1k
C21 0 NET0010 22n
C11 VCC 0 100n
C2 VCC 0 100n
C4 VCC 0 100n
C6 VCC 0 100n
C25 VCC 0 100n
C1 VCC 0 100n
R4 NET0003 VCC 10k
R7 NET0011 VCC 10k
R11 NET0012 VCC 10k
R5 NET0015 VCC 10k
R9 NET0016 VCC 10k
R8 NET0014 VCC 10k
C14 Net-_U1-C2N_ Net-_U1-C2P_ 1u
C24 Net-_U1-C1N_ Net-_U1-C1P_ 1u
C15 Net-_U1-VCOMH_ 0 4.7u
C5 Net-_U1-VCC_ 0 2.2u
R6 0 Net-_U1-IREF_ 390k
C3 VCC 0 1u
C18 VCC 0 1u

V_VCC VCC 0 DC 3.3

.control
tran 1m 10m
set filetype=ascii
write PCB_raw.raw all
.endc

.end
