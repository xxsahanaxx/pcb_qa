.title KiCad schematic

C22 VCC 0 4.7u
C12 VCC 0 4.7u
R11 VCC NET0006 10k
R12 NET0010 Net-_A1-BTN_ 1k
C6 0 NET0009 22n
C1 VCC 0 100n
C15 VCC 0 100n
C19 VCC 0 100n
C5 VCC 0 100n
C23 VCC 0 100n
C13 VCC 0 100n
R4 NET0007 VCC 10k
R5 NET0019 VCC 10k
R2 NET0016 VCC 10k
R3 NET0008 VCC 10k
R1 NET0012 VCC 10k
R6 NET0011 VCC 10k
C11 Net-_U1-C2N_ Net-_U1-C2P_ 1u
C8 Net-_U1-C1N_ Net-_U1-C1P_ 1u
C7 Net-_U1-VCOMH_ 0 4.7u
C9 Net-_U1-VCC_ 0 2.2u
R14 0 Net-_U1-IREF_ 390k
C3 VCC 0 1u
C21 VCC 0 1u

V_VCC VCC 0 DC 3.3

.control
tran 1m 10m
set filetype=ascii
write PCB_raw.raw all
.endc

.end
