.title KiCad schematic

C24 VCC 0 4.7u
C13 VCC 0 4.7u
R2 VCC NET0005 10k
R3 NET0006 Net-_A3-BTN_ 1k
C21 0 NET0001 22n
C19 VCC 0 100n
C18 VCC 0 100n
C15 VCC 0 100n
C16 VCC 0 100n
C6 VCC 0 100n
C4 VCC 0 100n
R10 NET0014 VCC 10k
R12 NET0013 VCC 10k
R14 NET0003 VCC 10k
R13 NET0002 VCC 10k
R8 NET0018 VCC 10k
R11 NET0012 VCC 10k
C1 Net-_U1-C2N_ Net-_U1-C2P_ 1u
C7 Net-_U1-C1N_ Net-_U1-C1P_ 1u
C25 Net-_U1-VCOMH_ 0 4.7u
C17 Net-_U1-VCC_ 0 2.2u
R1 0 Net-_U1-IREF_ 390k
C11 VCC 0 1u
C5 VCC 0 1u

V_VCC VCC 0 DC 3.3

.control
tran 1m 10m
set filetype=ascii
write PCB_raw.raw all
.endc

.end
