.title KiCad schematic

C1 VCC 0 4.7u
C15 VCC 0 4.7u
R4 VCC NET0019 10k
R14 NET0015 Net-_A3-BTN_ 1k
C19 0 NET0009 22n
C22 VCC 0 100n
C14 VCC 0 100n
C2 VCC 0 100n
C5 VCC 0 100n
C8 VCC 0 100n
C11 VCC 0 100n
R10 NET0010 VCC 10k
R7 NET0011 VCC 10k
R5 NET0014 VCC 10k
R13 NET0007 VCC 10k
R2 NET0002 VCC 10k
R3 NET0001 VCC 10k
C3 Net-_U3-C2N_ Net-_U3-C2P_ 1u
C13 Net-_U3-C1N_ Net-_U3-C1P_ 1u
C17 Net-_U3-VCOMH_ 0 4.7u
C20 Net-_U3-VCC_ 0 2.2u
R6 0 Net-_U3-IREF_ 390k
C12 VCC 0 1u
C25 VCC 0 1u

V_VCC VCC 0 DC 3.3

.control
tran 1m 10m
set filetype=ascii
write PCB_raw.raw all
.endc

.end
