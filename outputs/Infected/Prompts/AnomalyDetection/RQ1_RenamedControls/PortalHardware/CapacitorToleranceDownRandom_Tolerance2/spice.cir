.title KiCad schematic

C2 VCC 0 4.7u
C10 VCC 0 4.7u
R7 VCC NET0010 10k
R12 NET0018 Net-_A1-BTN_ 1k
C1 0 NET0004 22n
C16 VCC 0 100n
C23 VCC 0 100n
C4 VCC 0 100n
C19 VCC 0 100n
C25 VCC 0 100n
C14 VCC 0 100n
R10 NET0013 VCC 10k
R14 NET0019 VCC 10k
R2 NET0001 VCC 10k
R8 NET0017 VCC 10k
R4 NET0003 VCC 10k
R9 NET0014 VCC 10k
C8 Net-_U3-C2N_ Net-_U3-C2P_ 1u
C17 Net-_U3-C1N_ Net-_U3-C1P_ 1u
C6 Net-_U3-VCOMH_ 0 4.7u
C3 Net-_U3-VCC_ 0 2.2u
R3 0 Net-_U3-IREF_ 390k
C22 VCC 0 1u
C11 VCC 0 1u

V_VCC VCC 0 DC 3.3

.control
tran 1m 10m
set filetype=ascii
write PCB_raw.raw all
.endc

.end
