.title KiCad schematic

C22 VCC 0 4.7u
C14 VCC 0 4.7u
R5 VCC NET0018 10k
R1 NET0013 Net-_A3-BTN_ 1k
C6 0 NET0008 22n
C18 VCC 0 100n
C10 VCC 0 100n
C9 VCC 0 100n
C1 VCC 0 100n
C15 VCC 0 100n
C3 VCC 0 100n
R4 NET0002 VCC 10k
R13 NET0009 VCC 10k
R11 NET0003 VCC 10k
R7 NET0012 VCC 10k
R8 NET0006 VCC 10k
R10 NET0017 VCC 10k
C7 Net-_U1-C2N_ Net-_U1-C2P_ 1u
C21 Net-_U1-C1N_ Net-_U1-C1P_ 1u
C16 Net-_U1-VCOMH_ 0 4.7u
C13 Net-_U1-VCC_ 0 2.2u
R2 0 Net-_U1-IREF_ 390k
C25 VCC 0 1u
C11 VCC 0 1u

V_VCC VCC 0 DC 3.3

.control
tran 1m 10m
set filetype=ascii
write PCB_raw.raw all
.endc

.end
