.title KiCad schematic

C7 VCC 0 4.7u
C14 VCC 0 4.7u
R13 VCC NET0008 10k
R12 NET0012 Net-_A1-BTN_ 1k
C24 0 NET0015 22n
C2 VCC 0 100n
C19 VCC 0 100n
C9 VCC 0 100n
C18 VCC 0 100n
C16 VCC 0 100n
C21 VCC 0 100n
R10 NET0018 VCC 10k
R7 NET0002 VCC 10k
R14 NET0013 VCC 10k
R9 NET0006 VCC 10k
R3 NET0005 VCC 10k
R1 NET0007 VCC 10k
C3 Net-_U3-C2N_ Net-_U3-C2P_ 1u
C15 Net-_U3-C1N_ Net-_U3-C1P_ 1u
C13 Net-_U3-VCOMH_ 0 4.7u
C11 Net-_U3-VCC_ 0 2.2u
R8 0 Net-_U3-IREF_ 390k
C22 VCC 0 1u
C17 VCC 0 1u

V_VCC VCC 0 DC 3.3

.control
tran 1m 10m
set filetype=ascii
write PCB_raw.raw all
.endc

.end
