.title KiCad schematic

C14 VCC 0 4.7u
C8 VCC 0 4.7u
R14 VCC NET0014 10k
R4 NET0005 Net-_A3-BTN_ 1k
C7 0 NET0012 22n
C1 VCC 0 100n
C2 VCC 0 100n
C11 VCC 0 100n
C19 VCC 0 100n
C10 VCC 0 100n
C13 VCC 0 100n
R6 NET0017 VCC 10k
R5 NET0009 VCC 10k
R2 NET0006 VCC 10k
R3 NET0001 VCC 10k
R13 NET0011 VCC 10k
R12 NET0010 VCC 10k
C12 Net-_U2-C2N_ Net-_U2-C2P_ 1u
C22 Net-_U2-C1N_ Net-_U2-C1P_ 1u
C5 Net-_U2-VCOMH_ 0 4.7u
C3 Net-_U2-VCC_ 0 2.2u
R8 0 Net-_U2-IREF_ 390k
C4 VCC 0 1u
C6 VCC 0 1u

V_VCC VCC 0 DC 3.3

.control
tran 1m 10m
set filetype=ascii
write PCB_raw.raw all
.endc

.end
