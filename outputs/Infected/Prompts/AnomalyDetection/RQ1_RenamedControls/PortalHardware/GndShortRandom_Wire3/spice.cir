.title KiCad schematic

C17 VCC 0 4.7u
C18 VCC 0 4.7u
R12 VCC NET0019 10k
R9 NET0003 Net-_A1-BTN_ 1k
C25 0 NET0008 22n
C1 VCC 0 100n
C15 VCC 0 100n
C4 VCC 0 100n
C8 VCC 0 100n
C19 VCC 0 100n
C2 VCC 0 100n
R5 NET0012 VCC 10k
R13 NET0013 VCC 10k
R2 NET0005 VCC 10k
R14 NET0001 VCC 10k
R7 NET0009 VCC 10k
R6 NET0004 VCC 10k
C11 Net-_U1-C2N_ Net-_U1-C2P_ 1u
C5 Net-_U1-C1N_ Net-_U1-C1P_ 1u
C3 Net-_U1-VCOMH_ 0 4.7u
C14 Net-_U1-VCC_ 0 2.2u
R10 0 Net-_U1-IREF_ 390k
C21 VCC 0 1u
C13 VCC 0 1u

V_VCC VCC 0 DC 3.3

.control
tran 1m 10m
set filetype=ascii
write PCB_raw.raw all
.endc

.end
