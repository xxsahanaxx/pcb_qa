.title KiCad schematic

C3 VCC 0 4.7u
C10 VCC 0 4.7u
R9 VCC NET0014 10k
R6 NET0017 Net-_A3-BTN_ 1k
C8 0 NET0018 22n
C18 VCC 0 100n
C6 VCC 0 100n
C4 VCC 0 100n
C9 VCC 0 100n
C16 VCC 0 100n
C21 VCC 0 100n
R11 NET0013 VCC 10k
R14 NET0016 VCC 10k
R5 NET0005 VCC 10k
R12 NET0010 VCC 10k
R10 NET0011 VCC 10k
R1 NET0004 VCC 10k
C14 Net-_U2-C2N_ Net-_U2-C2P_ 1u
C17 Net-_U2-C1N_ Net-_U2-C1P_ 1u
C7 Net-_U2-VCOMH_ 0 4.7u
C5 Net-_U2-VCC_ 0 2.2u
R4 0 Net-_U2-IREF_ 390k
C13 VCC 0 1u
C19 VCC 0 1u

V_VCC VCC 0 DC 3.3

.control
tran 1m 10m
set filetype=ascii
write PCB_raw.raw all
.endc

.end
