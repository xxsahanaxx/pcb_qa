.title KiCad schematic

C23 VCC 0 4.7u
C14 VCC 0 4.7u
R1 VCC NET0002 10k
R2 NET0012 Net-_A3-BTN_ 1k
C9 0 NET0003 22n
C2 VCC 0 100n
C25 VCC 0 100n
C15 VCC 0 100n
C5 VCC 0 100n
C22 VCC 0 100n
C4 VCC 0 100n
R8 NET0017 VCC 10k
R12 NET0001 VCC 10k
R13 NET0014 VCC 10k
R14 NET0019 VCC 10k
R9 NET0009 VCC 10k
R5 NET0018 VCC 10k
C1 Net-_U2-C2N_ Net-_U2-C2P_ 1u
C13 Net-_U2-C1N_ Net-_U2-C1P_ 1u
C10 Net-_U2-VCOMH_ 0 4.7u
C19 Net-_U2-VCC_ 0 2.2u
R4 0 Net-_U2-IREF_ 390k
C8 VCC 0 1u
C3 VCC 0 1u

V_VCC VCC 0 DC 3.3

.control
tran 1m 10m
set filetype=ascii
write PCB_raw.raw all
.endc

.end
