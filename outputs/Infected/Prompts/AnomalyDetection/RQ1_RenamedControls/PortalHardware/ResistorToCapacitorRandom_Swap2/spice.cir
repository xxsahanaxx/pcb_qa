.title KiCad schematic

C20 VCC 0 4.7u
C14 VCC 0 4.7u
R5 VCC NET0003 10k
R14 NET0019 Net-_A3-BTN_ 1k
C8 0 NET0011 22n
C19 VCC 0 100n
C25 VCC 0 100n
C11 VCC 0 100n
C24 VCC 0 100n
C6 VCC 0 100n
C18 VCC 0 100n
R7 NET0015 VCC 10k
R12 NET0001 VCC 10k
R2 NET0002 VCC 10k
R13 NET0004 VCC 10k
R9 NET0013 VCC 10k
R8 NET0009 VCC 10k
C10 Net-_U3-C2N_ Net-_U3-C2P_ 1u
C7 Net-_U3-C1N_ Net-_U3-C1P_ 1u
C1 Net-_U3-VCOMH_ 0 4.7u
C13 Net-_U3-VCC_ 0 2.2u
R3 0 Net-_U3-IREF_ 390k
C15 VCC 0 1u
C21 VCC 0 1u

V_VCC VCC 0 DC 3.3

.control
tran 1m 10m
set filetype=ascii
write PCB_raw.raw all
.endc

.end
