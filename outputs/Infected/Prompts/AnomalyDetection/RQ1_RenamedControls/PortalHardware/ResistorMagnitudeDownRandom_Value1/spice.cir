.title KiCad schematic

C10 VCC 0 4.7u
C7 VCC 0 4.7u
R7 VCC NET0005 10k
R1 NET0007 Net-_A1-BTN_ 1k
C5 0 NET0006 22n
C20 VCC 0 100n
C19 VCC 0 100n
C18 VCC 0 100n
C21 VCC 0 100n
C2 VCC 0 100n
C16 VCC 0 100n
R4 NET0012 VCC 10k
R6 NET0015 VCC 10k
R5 NET0018 VCC 10k
R11 NET0008 VCC 10k
R2 NET0011 VCC 10k
R8 NET0019 VCC 10k
C12 Net-_U3-C2N_ Net-_U3-C2P_ 1u
C8 Net-_U3-C1N_ Net-_U3-C1P_ 1u
C3 Net-_U3-VCOMH_ 0 4.7u
C23 Net-_U3-VCC_ 0 2.2u
R12 0 Net-_U3-IREF_ 390k
C4 VCC 0 1u
C25 VCC 0 1u

V_VCC VCC 0 DC 3.3

.control
tran 1m 10m
set filetype=ascii
write PCB_raw.raw all
.endc

.end
