.title KiCad schematic

C18 VCC 0 4.7u
C9 VCC 0 4.7u
R1 VCC NET0015 10k
R2 NET0017 Net-_A1-BTN_ 1k
C19 0 NET0006 22n
C23 VCC 0 100n
C17 VCC 0 100n
C2 VCC 0 100n
C15 VCC 0 100n
C7 VCC 0 100n
C11 VCC 0 100n
R3 NET0003 VCC 10k
R14 NET0005 VCC 10k
R12 NET0014 VCC 10k
R13 NET0002 VCC 10k
R4 NET0009 VCC 10k
R5 NET0013 VCC 10k
C14 Net-_U1-C2N_ Net-_U1-C2P_ 1u
C10 Net-_U1-C1N_ Net-_U1-C1P_ 1u
C6 Net-_U1-VCOMH_ 0 4.7u
C21 Net-_U1-VCC_ 0 2.2u
R11 0 Net-_U1-IREF_ 390k
C22 VCC 0 1u
C3 VCC 0 1u

V_VCC VCC 0 DC 3.3

.control
tran 1m 10m
set filetype=ascii
write PCB_raw.raw all
.endc

.end
