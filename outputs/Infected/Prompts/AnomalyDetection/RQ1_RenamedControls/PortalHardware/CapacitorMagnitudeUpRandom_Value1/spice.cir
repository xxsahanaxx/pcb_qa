.title KiCad schematic

C16 VCC 0 4.7u
C9 VCC 0 4.7u
R1 VCC NET0014 10k
R12 NET0004 Net-_A1-BTN_ 1k
C17 0 NET0008 22n
C13 VCC 0 100n
C23 VCC 0 100n
C7 VCC 0 100n
C12 VCC 0 100n
C8 VCC 0 100n
C20 VCC 0 100n
R7 NET0005 VCC 10k
R4 NET0015 VCC 10k
R11 NET0013 VCC 10k
R3 NET0011 VCC 10k
R8 NET0001 VCC 10k
R6 NET0018 VCC 10k
C14 Net-_U3-C2N_ Net-_U3-C2P_ 1u
C21 Net-_U3-C1N_ Net-_U3-C1P_ 1u
C2 Net-_U3-VCOMH_ 0 4.7u
C19 Net-_U3-VCC_ 0 2.2u
R14 0 Net-_U3-IREF_ 390k
C18 VCC 0 1u
C15 VCC 0 1u

V_VCC VCC 0 DC 3.3

.control
tran 1m 10m
set filetype=ascii
write PCB_raw.raw all
.endc

.end
