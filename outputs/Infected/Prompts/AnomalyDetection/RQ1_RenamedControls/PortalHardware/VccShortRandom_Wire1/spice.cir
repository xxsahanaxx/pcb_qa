.title KiCad schematic

C3 VCC 0 4.7u
C17 VCC 0 4.7u
R2 VCC NET0013 10k
R4 NET0016 Net-_A3-BTN_ 1k
C18 0 NET0015 22n
C23 VCC 0 100n
C11 VCC 0 100n
C22 VCC 0 100n
C16 VCC 0 100n
C10 VCC 0 100n
C21 VCC 0 100n
R7 NET0010 VCC 10k
R11 NET0005 VCC 10k
R8 NET0012 VCC 10k
R10 NET0002 VCC 10k
R3 NET0017 VCC 10k
R5 NET0019 VCC 10k
C14 Net-_U1-C2N_ Net-_U1-C2P_ 1u
C19 Net-_U1-C1N_ Net-_U1-C1P_ 1u
C13 Net-_U1-VCOMH_ 0 4.7u
C6 Net-_U1-VCC_ 0 2.2u
R12 0 Net-_U1-IREF_ 390k
C2 VCC 0 1u
C24 VCC 0 1u

V_VCC VCC 0 DC 3.3

.control
tran 1m 10m
set filetype=ascii
write PCB_raw.raw all
.endc

.end
