.title KiCad schematic

C1 VCC 0 4.7u
C19 VCC 0 4.7u
R6 VCC NET0009 10k
R9 NET0017 Net-_A3-BTN_ 1k
C15 0 NET0006 22n
C22 VCC 0 100n
C13 VCC 0 100n
C16 VCC 0 100n
C14 VCC 0 100n
C8 VCC 0 100n
C4 VCC 0 100n
R12 NET0001 VCC 10k
R5 NET0008 VCC 10k
R11 NET0015 VCC 10k
R7 NET0010 VCC 10k
R2 NET0013 VCC 10k
R4 NET0014 VCC 10k
C3 Net-_U3-C2N_ Net-_U3-C2P_ 1u
C21 Net-_U3-C1N_ Net-_U3-C1P_ 1u
C6 Net-_U3-VCOMH_ 0 4.7u
C17 Net-_U3-VCC_ 0 2.2u
R10 0 Net-_U3-IREF_ 390k
C20 VCC 0 1u
C11 VCC 0 1u

V_VCC VCC 0 DC 3.3

.control
tran 1m 10m
set filetype=ascii
write PCB_raw.raw all
.endc

.end
