.title KiCad schematic

C23 VCC 0 4.7u
C17 VCC 0 4.7u
R3 VCC NET0013 10k
R4 NET0005 Net-_A3-BTN_ 1k
C2 0 NET0011 22n
C12 VCC 0 100n
C8 VCC 0 100n
C14 VCC 0 100n
C20 VCC 0 100n
C18 VCC 0 100n
C22 VCC 0 100n
R2 NET0009 VCC 10k
R13 NET0014 VCC 10k
R7 NET0003 VCC 10k
R14 NET0015 VCC 10k
R11 NET0010 VCC 10k
R9 NET0007 VCC 10k
C25 Net-_U3-C2N_ Net-_U3-C2P_ 1u
C13 Net-_U3-C1N_ Net-_U3-C1P_ 1u
C4 Net-_U3-VCOMH_ 0 4.7u
C19 Net-_U3-VCC_ 0 2.2u
R8 0 Net-_U3-IREF_ 390k
C7 VCC 0 1u
C1 VCC 0 1u

V_VCC VCC 0 DC 3.3

.control
tran 1m 10m
set filetype=ascii
write PCB_raw.raw all
.endc

.end
