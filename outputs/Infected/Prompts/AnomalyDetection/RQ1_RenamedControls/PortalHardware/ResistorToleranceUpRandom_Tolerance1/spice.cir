.title KiCad schematic

C19 VCC 0 4.7u
C17 VCC 0 4.7u
R12 VCC NET0014 10k
R5 NET0007 Net-_A3-BTN_ 1k
C2 0 NET0004 22n
C12 VCC 0 100n
C18 VCC 0 100n
C25 VCC 0 100n
C24 VCC 0 100n
C14 VCC 0 100n
C23 VCC 0 100n
R10 NET0018 VCC 10k
R13 NET0005 VCC 10k
R4 NET0011 VCC 10k
R6 NET0019 VCC 10k
R8 NET0008 VCC 10k
R11 NET0012 VCC 10k
C16 Net-_U2-C2N_ Net-_U2-C2P_ 1u
C21 Net-_U2-C1N_ Net-_U2-C1P_ 1u
C10 Net-_U2-VCOMH_ 0 4.7u
C3 Net-_U2-VCC_ 0 2.2u
R9 0 Net-_U2-IREF_ 390k
C8 VCC 0 1u
C6 VCC 0 1u

V_VCC VCC 0 DC 3.3

.control
tran 1m 10m
set filetype=ascii
write PCB_raw.raw all
.endc

.end
