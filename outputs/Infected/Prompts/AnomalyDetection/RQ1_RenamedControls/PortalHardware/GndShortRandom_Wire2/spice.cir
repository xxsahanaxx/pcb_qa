.title KiCad schematic

C1 VCC 0 4.7u
C14 VCC 0 4.7u
R3 VCC NET0003 10k
R6 NET0019 Net-_A1-BTN_ 1k
C16 0 NET0017 22n
C10 VCC 0 100n
C6 VCC 0 100n
C19 VCC 0 100n
C12 VCC 0 100n
C11 VCC 0 100n
C18 VCC 0 100n
R8 NET0002 VCC 10k
R5 NET0005 VCC 10k
R1 NET0010 VCC 10k
R10 NET0013 VCC 10k
R12 NET0007 VCC 10k
R13 NET0008 VCC 10k
C22 Net-_U2-C2N_ Net-_U2-C2P_ 1u
C25 Net-_U2-C1N_ Net-_U2-C1P_ 1u
C4 Net-_U2-VCOMH_ 0 4.7u
C24 Net-_U2-VCC_ 0 2.2u
R9 0 Net-_U2-IREF_ 390k
C21 VCC 0 1u
C3 VCC 0 1u

V_VCC VCC 0 DC 3.3

.control
tran 1m 10m
set filetype=ascii
write PCB_raw.raw all
.endc

.end
