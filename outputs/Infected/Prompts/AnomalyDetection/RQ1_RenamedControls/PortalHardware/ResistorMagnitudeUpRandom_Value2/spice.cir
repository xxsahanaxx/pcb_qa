.title KiCad schematic

C18 VCC 0 4.7u
C17 VCC 0 4.7u
R1 VCC NET0015 10k
R4 NET0011 Net-_A1-BTN_ 1k
C13 0 NET0007 22n
C3 VCC 0 100n
C19 VCC 0 100n
C11 VCC 0 100n
C4 VCC 0 100n
C9 VCC 0 100n
C24 VCC 0 100n
R13 NET0014 VCC 10k
R10 NET0013 VCC 10k
R7 NET0009 VCC 10k
R11 NET0012 VCC 10k
R8 NET0008 VCC 10k
R3 NET0017 VCC 10k
C22 Net-_U3-C2N_ Net-_U3-C2P_ 1u
C5 Net-_U3-C1N_ Net-_U3-C1P_ 1u
C21 Net-_U3-VCOMH_ 0 4.7u
C23 Net-_U3-VCC_ 0 2.2u
R6 0 Net-_U3-IREF_ 390k
C25 VCC 0 1u
C7 VCC 0 1u

V_VCC VCC 0 DC 3.3

.control
tran 1m 10m
set filetype=ascii
write PCB_raw.raw all
.endc

.end
