.title KiCad schematic

R10 /NET0013 /NET0004 0
R20 /NET0010 /NET0003 0
R13 /NET0013 /NET0009 0
R4 /NET0010 /NET0023 0
C6 +3V3 0 0.1u
R1 +3V3 /NET0024 2k
R5 +3V3 Net-_U2-B_ 2.2k
R24 Net-_U2-B_ 0 2.2k
R7 /NET0024 Net-_J5-Pin_3_ 0
C4 Net-_D1-K_ 0 100u
C2 0 Net-_D1-K_ 100u
R8 Net-_J5-Pin_3_ /NET0010 1k
C1 0 Net-_D1-K_ 100u
R22 Net-_J5-Pin_3_ Net-_J7-Pin_3_ 0
C3 0 Net-_D1-K_ 100u
R11 Net-_J7-Pin_3_ /NET0013 1k
R23 Net-_Q2-G_ Net-_J2-Pin_1_ 47k
R14 /NET0038 Net-_Q3-B_ 5.1k
R19 +3V3 /NET0038 10k
R18 Net-_Q3-C_ 0 20k

V_3V3 +3V3 0 DC 3.3

.control
tran 100u 10m
set filetype=ascii
write m5-pantilt_raw.raw all
.endc

.end
