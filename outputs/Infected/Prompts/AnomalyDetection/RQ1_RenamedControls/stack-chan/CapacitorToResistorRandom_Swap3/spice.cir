.title KiCad schematic

R19 /NET0011 /NET0038 0
R16 /NET0042 /NET0008 0
R8 /NET0011 /NET0036 0
R14 /NET0042 /NET0013 0
C4 +3V3 0 0.1u
R21 +3V3 /NET0016 2k
R10 +3V3 Net-_U2-B_ 2.2k
R22 Net-_U2-B_ 0 2.2k
R1 /NET0016 Net-_J7-Pin_3_ 0
R6 Net-_J7-Pin_3_ Net-_J2-Pin_3_ 0
C5 0 Net-_D1-K_ 100u
C2 0 Net-_D1-K_ 100u
R2 Net-_J2-Pin_3_ /NET0011 1k
C1 0 Net-_D1-K_ 100u
C7 Net-_D1-K_ 0 100u
R15 Net-_J7-Pin_3_ /NET0042 1k
R7 Net-_Q2-G_ Net-_J6-Pin_1_ 47k
R24 /NET0030 Net-_Q3-B_ 5.1k
R3 +3V3 /NET0030 10k
R5 Net-_Q3-C_ 0 20k

V_3V3 +3V3 0 DC 3.3

.control
tran 100u 10m
set filetype=ascii
write m5-pantilt_raw.raw all
.endc

.end
