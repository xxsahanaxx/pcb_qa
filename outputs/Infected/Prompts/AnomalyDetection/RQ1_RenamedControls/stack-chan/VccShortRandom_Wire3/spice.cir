.title KiCad schematic

R16 /NET0042 /NET0011 0
R3 /NET0036 /NET0038 0
R18 /NET0042 /NET0015 0
R10 /NET0036 /NET0028 0
C4 +3V3 0 0.1u
R12 +3V3 /NET0030 2k
R4 +3V3 Net-_U2-B_ 2.2k
R20 Net-_U2-B_ 0 2.2k
R1 /NET0030 Net-_J3-Pin_3_ 0
R17 Net-_J3-Pin_3_ Net-_J1-Pin_3_ 0
C3 0 Net-_D3-K_ 100u
C6 0 Net-_D3-K_ 100u
R23 Net-_J1-Pin_3_ /NET0042 1k
C1 0 Net-_D3-K_ 100u
C2 Net-_D3-K_ 0 100u
R14 Net-_J3-Pin_3_ /NET0036 1k
R9 Net-_Q2-G_ Net-_J8-Pin_1_ 47k
R24 /NET0024 Net-_Q1-B_ 5.1k
R13 +3V3 /NET0024 10k
R8 Net-_Q1-C_ 0 20k

V_3V3 +3V3 0 DC 3.3

.control
tran 100u 10m
set filetype=ascii
write m5-pantilt_raw.raw all
.endc

.end
