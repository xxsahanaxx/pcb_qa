.title KiCad schematic

R23 /NET0009 /NET0041 0
R21 /NET0008 /NET0025 0
R2 /NET0009 /NET0004 0
R24 /NET0008 /NET0040 0
C6 +3V3 0 0.1u
R4 +3V3 /NET0038 2k
R16 +3V3 Net-_U2-B_ 2.2k
R17 Net-_U2-B_ 0 2.2k
R13 /NET0038 Net-_J4-Pin_3_ 0
R19 Net-_J4-Pin_3_ Net-_J1-Pin_3_ 0
C7 0 Net-_D1-K_ 100u
C3 0 Net-_D1-K_ 100u
R20 Net-_J1-Pin_3_ /NET0009 1k
C2 0 Net-_D1-K_ 100u
C1 Net-_D1-K_ 0 100u
R14 Net-_J4-Pin_3_ /NET0008 1k
R10 Net-_Q2-G_ Net-_J10-Pin_1_ 47k
R1 /NET0035 Net-_Q3-B_ 5.1k
R3 +3V3 /NET0035 10k
R6 Net-_Q3-C_ 0 20k

V_3V3 +3V3 0 DC 3.3

.control
tran 100u 10m
set filetype=ascii
write m5-pantilt_raw.raw all
.endc

.end
