.title KiCad schematic

R1 /NET0039 /NET0010 0
R5 /NET0003 /NET0038 0
R23 /NET0039 /NET0029 0
R14 /NET0003 /NET0033 0
C8 +3V3 0 0.1u
R22 +3V3 /NET0031 2k
R24 +3V3 Net-_U2-B_ 2.2k
R13 Net-_U2-B_ 0 2.2k
R21 /NET0031 Net-_J6-Pin_3_ 0
R8 Net-_J6-Pin_3_ Net-_J11-Pin_3_ 0
C6 0 Net-_D1-K_ 100u
C2 0 Net-_D1-K_ 100u
R2 Net-_J11-Pin_3_ /NET0039 1k
C1 0 Net-_D1-K_ 100u
C7 Net-_D1-K_ 0 100u
R20 Net-_J6-Pin_3_ /NET0003 1k
R6 Net-_Q2-G_ Net-_J3-Pin_1_ 47k
R3 /NET0015 Net-_Q3-B_ 5.1k
R7 +3V3 /NET0015 10k
R4 Net-_Q3-C_ 0 20k

V_3V3 +3V3 0 DC 3.3

.control
tran 100u 10m
set filetype=ascii
write m5-pantilt_raw.raw all
.endc

.end
