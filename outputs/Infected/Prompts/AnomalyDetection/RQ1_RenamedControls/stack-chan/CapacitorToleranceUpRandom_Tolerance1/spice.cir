.title KiCad schematic

R8 /NET0021 /NET0039 0
R5 /NET0034 /NET0023 0
R22 /NET0021 /NET0025 0
R6 /NET0034 /NET0009 0
C1 +3V3 0 0.1u
R23 +3V3 /NET0019 2k
R7 +3V3 Net-_U2-B_ 2.2k
R13 Net-_U2-B_ 0 2.2k
R20 /NET0019 Net-_J11-Pin_3_ 0
R12 Net-_J11-Pin_3_ Net-_J4-Pin_3_ 0
C6 0 Net-_D3-K_ 100u
C3 0 Net-_D3-K_ 100u
R10 Net-_J4-Pin_3_ /NET0021 1k
C8 0 Net-_D3-K_ 100u
C4 Net-_D3-K_ 0 100u
R15 Net-_J11-Pin_3_ /NET0034 1k
R24 Net-_Q2-G_ Net-_J2-Pin_1_ 47k
R17 /NET0031 Net-_Q3-B_ 5.1k
R9 +3V3 /NET0031 10k
R14 Net-_Q3-C_ 0 20k

V_3V3 +3V3 0 DC 3.3

.control
tran 100u 10m
set filetype=ascii
write m5-pantilt_raw.raw all
.endc

.end
