.title KiCad schematic

R16 /NET0024 /NET0004 0
R21 /NET0019 /NET0035 0
R23 /NET0024 /NET0039 0
R2 /NET0019 /NET0012 0
C8 +3V3 0 0.1u
R8 +3V3 /NET0041 2k
R5 +3V3 Net-_U2-B_ 2.2k
R18 Net-_U2-B_ 0 2.2k
R17 /NET0041 Net-_J10-Pin_3_ 0
C7 Net-_D3-K_ 0 100u
C5 0 Net-_D3-K_ 100u
R1 Net-_J10-Pin_3_ /NET0019 1k
C1 0 Net-_D3-K_ 100u
R7 Net-_J10-Pin_3_ Net-_J11-Pin_3_ 0
C4 0 Net-_D3-K_ 100u
R19 Net-_J11-Pin_3_ /NET0024 1k
R14 Net-_Q3-G_ Net-_J6-Pin_1_ 47k
R9 /NET0040 Net-_Q1-B_ 5.1k
R24 +3V3 /NET0040 10k
R22 Net-_Q1-C_ 0 20k

V_3V3 +3V3 0 DC 3.3

.control
tran 100u 10m
set filetype=ascii
write m5-pantilt_raw.raw all
.endc

.end
