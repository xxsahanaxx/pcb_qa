.title KiCad schematic

R24 /NET0030 /NET0027 0
R4 /NET0017 /NET0021 0
R22 /NET0030 /NET0015 0
R19 /NET0017 /NET0028 0
C3 +3V3 0 0.1u
R15 +3V3 /NET0025 2k
R10 +3V3 Net-_U2-B_ 2.2k
R1 Net-_U2-B_ 0 2.2k
R3 /NET0025 Net-_J10-Pin_3_ 0
R20 Net-_J10-Pin_3_ Net-_J1-Pin_3_ 0
C5 0 Net-_D1-K_ 100u
C2 0 Net-_D1-K_ 100u
R16 Net-_J1-Pin_3_ /NET0030 1k
C8 0 Net-_D1-K_ 100u
C1 Net-_D1-K_ 0 100u
R13 Net-_J10-Pin_3_ /NET0017 1k
R21 Net-_Q2-G_ Net-_J4-Pin_1_ 47k
R17 /NET0011 Net-_Q3-B_ 5.1k
R8 +3V3 /NET0011 10k
R6 Net-_Q3-C_ 0 20k

V_3V3 +3V3 0 DC 3.3

.control
tran 100u 10m
set filetype=ascii
write m5-pantilt_raw.raw all
.endc

.end
