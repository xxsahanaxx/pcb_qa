.title KiCad schematic

R23 /NET0001 /NET0014 0
R18 /NET0021 /NET0002 0
R12 /NET0001 /NET0041 0
R7 /NET0021 /NET0028 0
C7 +3V3 0 0.1u
R21 +3V3 /NET0020 2k
R22 +3V3 Net-_U2-B_ 2.2k
R1 Net-_U2-B_ 0 2.2k
R4 /NET0020 Net-_J4-Pin_3_ 0
R8 Net-_J4-Pin_3_ Net-_J8-Pin_3_ 0
C8 0 Net-_D1-K_ 100u
C2 0 Net-_D1-K_ 100u
R17 Net-_J8-Pin_3_ /NET0001 1k
C3 0 Net-_D1-K_ 100u
C4 Net-_D1-K_ 0 100u
R11 Net-_J4-Pin_3_ /NET0021 1k
R10 Net-_Q3-G_ Net-_J11-Pin_1_ 47k
R13 /NET0012 Net-_Q1-B_ 5.1k
R16 +3V3 /NET0012 10k
R15 Net-_Q1-C_ 0 20k

V_3V3 +3V3 0 DC 3.3

.control
tran 100u 10m
set filetype=ascii
write m5-pantilt_raw.raw all
.endc

.end
