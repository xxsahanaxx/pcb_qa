.title KiCad schematic

R10 /NET0027 /NET0015 0
R19 /NET0001 /NET0038 0
R6 /NET0027 /NET0040 0
R22 /NET0001 /NET0010 0
C3 +3V3 0 0.1u
R21 +3V3 /NET0017 2k
R5 +3V3 Net-_U2-B_ 2.2k
R9 Net-_U2-B_ 0 2.2k
R16 /NET0017 Net-_J2-Pin_3_ 0
C1 Net-_D1-K_ 0 100u
C6 0 Net-_D1-K_ 100u
R1 Net-_J2-Pin_3_ /NET0001 1k
C8 0 Net-_D1-K_ 100u
R23 Net-_J2-Pin_3_ Net-_J8-Pin_3_ 0
C4 0 Net-_D1-K_ 100u
R13 Net-_J8-Pin_3_ /NET0027 1k
R20 Net-_Q2-G_ Net-_J10-Pin_1_ 47k
R24 /NET0028 Net-_Q3-B_ 5.1k
R4 +3V3 /NET0028 10k
R11 Net-_Q3-C_ 0 20k

V_3V3 +3V3 0 DC 3.3

.control
tran 100u 10m
set filetype=ascii
write m5-pantilt_raw.raw all
.endc

.end
