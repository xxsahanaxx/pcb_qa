.title KiCad schematic

R18 /NET0017 /NET0032 0
R11 /NET0007 /NET0010 0
R2 /NET0017 /NET0019 0
R19 /NET0007 /NET0003 0
C4 +3V3 0 0.1u
R3 +3V3 /NET0024 2k
R14 +3V3 Net-_U2-B_ 2.2k
R9 Net-_U2-B_ 0 2.2k
R4 /NET0024 Net-_J1-Pin_3_ 0
R1 Net-_J1-Pin_3_ Net-_J2-Pin_3_ 0
C7 0 Net-_D3-K_ 100u
C3 0 Net-_D3-K_ 100u
R17 Net-_J2-Pin_3_ /NET0017 1k
C8 0 Net-_D3-K_ 100u
C6 Net-_D3-K_ 0 100u
R24 Net-_J1-Pin_3_ /NET0007 1k
R13 Net-_Q2-G_ Net-_J8-Pin_1_ 47k
R7 /NET0015 Net-_Q3-B_ 5.1k
R10 +3V3 /NET0015 10k
R20 Net-_Q3-C_ 0 20k

V_3V3 +3V3 0 DC 3.3

.control
tran 100u 10m
set filetype=ascii
write m5-pantilt_raw.raw all
.endc

.end
