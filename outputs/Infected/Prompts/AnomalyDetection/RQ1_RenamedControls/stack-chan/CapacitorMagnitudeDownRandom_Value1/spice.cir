.title KiCad schematic

R1 /NET0038 /NET0006 0
R14 /NET0028 /NET0030 0
R20 /NET0038 /NET0008 0
R23 /NET0028 /NET0017 0
C2 +3V3 0 0.1u
R10 +3V3 /NET0018 2k
R16 +3V3 Net-_U2-B_ 2.2k
R7 Net-_U2-B_ 0 2.2k
R11 /NET0018 Net-_J5-Pin_3_ 0
C7 Net-_D1-K_ 0 100u
C8 0 Net-_D1-K_ 100u
R9 Net-_J5-Pin_3_ /NET0028 1k
C4 0 Net-_D1-K_ 100u
R2 Net-_J5-Pin_3_ Net-_J11-Pin_3_ 0
C3 0 Net-_D1-K_ 100u
R24 Net-_J11-Pin_3_ /NET0038 1k
R22 Net-_Q2-G_ Net-_J4-Pin_1_ 47k
R17 /NET0041 Net-_Q1-B_ 5.1k
R12 +3V3 /NET0041 10k
R15 Net-_Q1-C_ 0 20k

V_3V3 +3V3 0 DC 3.3

.control
tran 100u 10m
set filetype=ascii
write m5-pantilt_raw.raw all
.endc

.end
