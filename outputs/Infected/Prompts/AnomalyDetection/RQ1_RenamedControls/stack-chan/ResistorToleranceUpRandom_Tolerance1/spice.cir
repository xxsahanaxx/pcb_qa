.title KiCad schematic

R6 /NET0041 /NET0008 0
R19 /NET0021 /NET0036 0
R5 /NET0041 /NET0024 0
R17 /NET0021 /NET0032 0
C2 +3V3 0 0.1u
R12 +3V3 /NET0013 2k
R15 +3V3 Net-_U2-B_ 2.2k
R9 Net-_U2-B_ 0 2.2k
R8 /NET0013 Net-_J1-Pin_3_ 0
C5 Net-_D3-K_ 0 100u
C8 0 Net-_D3-K_ 100u
R3 Net-_J1-Pin_3_ /NET0021 1k
C1 0 Net-_D3-K_ 100u
R24 Net-_J1-Pin_3_ Net-_J11-Pin_3_ 0
C4 0 Net-_D3-K_ 100u
R23 Net-_J11-Pin_3_ /NET0041 1k
R11 Net-_Q3-G_ Net-_J2-Pin_1_ 47k
R22 /NET0009 Net-_Q1-B_ 5.1k
R4 +3V3 /NET0009 10k
R21 Net-_Q1-C_ 0 20k

V_3V3 +3V3 0 DC 3.3

.control
tran 100u 10m
set filetype=ascii
write m5-pantilt_raw.raw all
.endc

.end
