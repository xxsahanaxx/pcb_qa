.title KiCad schematic

R23 /NET0009 /NET0018 0
R1 /NET0041 /NET0002 0
R9 /NET0009 /NET0014 0
R6 /NET0041 /NET0016 0
C4 +3V3 0 0.1u
R22 +3V3 /NET0030 2k
R19 +3V3 Net-_U2-B_ 2.2k
R17 Net-_U2-B_ 0 2.2k
R20 /NET0030 Net-_J5-Pin_3_ 0
R2 Net-_J5-Pin_3_ Net-_J2-Pin_3_ 0
C8 0 Net-_D3-K_ 100u
C3 0 Net-_D3-K_ 100u
R5 Net-_J2-Pin_3_ /NET0009 1k
C7 0 Net-_D3-K_ 100u
C2 Net-_D3-K_ 0 100u
R14 Net-_J5-Pin_3_ /NET0041 1k
R10 Net-_Q2-G_ Net-_J1-Pin_1_ 47k
R3 /NET0027 Net-_Q3-B_ 5.1k
R4 +3V3 /NET0027 10k
R12 Net-_Q3-C_ 0 20k

V_3V3 +3V3 0 DC 3.3

.control
tran 100u 10m
set filetype=ascii
write m5-pantilt_raw.raw all
.endc

.end
