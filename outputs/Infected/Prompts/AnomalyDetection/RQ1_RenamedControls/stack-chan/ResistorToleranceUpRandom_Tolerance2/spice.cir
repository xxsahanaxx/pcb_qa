.title KiCad schematic

R11 /NET0005 /NET0013 0
R19 /NET0025 /NET0034 0
R24 /NET0005 /NET0029 0
R18 /NET0025 /NET0023 0
C2 +3V3 0 0.1u
R13 +3V3 /NET0040 2k
R7 +3V3 Net-_U2-B_ 2.2k
R8 Net-_U2-B_ 0 2.2k
R22 /NET0040 Net-_J9-Pin_3_ 0
C8 Net-_D3-K_ 0 100u
C3 0 Net-_D3-K_ 100u
R3 Net-_J9-Pin_3_ /NET0025 1k
C1 0 Net-_D3-K_ 100u
R15 Net-_J9-Pin_3_ Net-_J1-Pin_3_ 0
C5 0 Net-_D3-K_ 100u
R9 Net-_J1-Pin_3_ /NET0005 1k
R23 Net-_Q3-G_ Net-_J8-Pin_1_ 47k
R16 /NET0015 Net-_Q1-B_ 5.1k
R10 +3V3 /NET0015 10k
R2 Net-_Q1-C_ 0 20k

V_3V3 +3V3 0 DC 3.3

.control
tran 100u 10m
set filetype=ascii
write m5-pantilt_raw.raw all
.endc

.end
