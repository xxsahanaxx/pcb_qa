.title KiCad schematic

R4 /NET0017 /NET0011 0
R7 /NET0041 /NET0015 0
R5 /NET0017 /NET0043 0
R1 /NET0041 /NET0003 0
C4 +3V3 0 0.1u
R2 +3V3 /NET0001 2k
R24 +3V3 Net-_U2-B_ 2.2k
R14 Net-_U2-B_ 0 2.2k
R22 /NET0001 Net-_J6-Pin_3_ 0
R10 Net-_J6-Pin_3_ Net-_J10-Pin_3_ 0
C6 0 Net-_D3-K_ 100u
C8 0 Net-_D3-K_ 100u
R16 Net-_J10-Pin_3_ /NET0017 1k
C1 0 Net-_D3-K_ 100u
C7 Net-_D3-K_ 0 100u
R18 Net-_J6-Pin_3_ /NET0041 1k
R8 Net-_Q3-G_ Net-_J2-Pin_1_ 47k
R21 /NET0040 Net-_Q1-B_ 5.1k
R9 +3V3 /NET0040 10k
R12 Net-_Q1-C_ 0 20k

V_3V3 +3V3 0 DC 3.3

.control
tran 100u 10m
set filetype=ascii
write m5-pantilt_raw.raw all
.endc

.end
