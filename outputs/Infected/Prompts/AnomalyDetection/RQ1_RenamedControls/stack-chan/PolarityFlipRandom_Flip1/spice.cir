.title KiCad schematic

R10 /NET0038 /NET0030 0
R8 /NET0041 /NET0002 0
R22 /NET0038 /NET0011 0
R3 /NET0041 /NET0021 0
C3 +3V3 0 0.1u
R4 +3V3 /NET0023 2k
R1 +3V3 Net-_U2-B_ 2.2k
R5 Net-_U2-B_ 0 2.2k
R23 /NET0023 Net-_J4-Pin_3_ 0
R21 Net-_J4-Pin_3_ Net-_J2-Pin_3_ 0
C1 0 Net-_D3-K_ 100u
C5 0 Net-_D3-K_ 100u
R7 Net-_J2-Pin_3_ /NET0038 1k
C2 0 Net-_D3-K_ 100u
C7 Net-_D3-K_ 0 100u
R12 Net-_J4-Pin_3_ /NET0041 1k
R9 Net-_Q2-G_ Net-_J6-Pin_1_ 47k
R6 /NET0010 Net-_Q3-B_ 5.1k
R14 +3V3 /NET0010 10k
R13 Net-_Q3-C_ 0 20k

V_3V3 +3V3 0 DC 3.3

.control
tran 100u 10m
set filetype=ascii
write m5-pantilt_raw.raw all
.endc

.end
