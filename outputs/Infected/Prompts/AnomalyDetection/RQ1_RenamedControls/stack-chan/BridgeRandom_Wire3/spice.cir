.title KiCad schematic

R15 /NET0007 /NET0010 0
R8 /NET0032 /NET0042 0
R9 /NET0007 /NET0022 0
R7 /NET0032 /NET0006 0
C8 +3V3 0 0.1u
R17 +3V3 /NET0001 2k
R16 +3V3 Net-_U2-B_ 2.2k
R1 Net-_U2-B_ 0 2.2k
R24 /NET0001 Net-_J1-Pin_3_ 0
R3 Net-_J1-Pin_3_ Net-_J8-Pin_3_ 0
C7 0 Net-_D1-K_ 100u
C5 0 Net-_D1-K_ 100u
R6 Net-_J8-Pin_3_ /NET0007 1k
C3 0 Net-_D1-K_ 100u
C2 Net-_D1-K_ 0 100u
R23 Net-_J1-Pin_3_ /NET0032 1k
R19 Net-_Q2-G_ Net-_J3-Pin_1_ 47k
R22 /NET0009 Net-_Q3-B_ 5.1k
R11 +3V3 /NET0009 10k
R5 Net-_Q3-C_ 0 20k

V_3V3 +3V3 0 DC 3.3

.control
tran 100u 10m
set filetype=ascii
write m5-pantilt_raw.raw all
.endc

.end
