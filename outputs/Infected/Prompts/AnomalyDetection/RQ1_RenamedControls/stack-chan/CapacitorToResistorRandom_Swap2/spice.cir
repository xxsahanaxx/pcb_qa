.title KiCad schematic

R20 /NET0038 /NET0044 0
R23 /NET0029 /NET0032 0
R14 /NET0038 /NET0024 0
R4 /NET0029 /NET0022 0
C8 +3V3 0 0.1u
R13 +3V3 /NET0030 2k
R12 +3V3 Net-_U2-B_ 2.2k
R11 Net-_U2-B_ 0 2.2k
R17 /NET0030 Net-_J5-Pin_3_ 0
C1 Net-_D1-K_ 0 100u
C7 0 Net-_D1-K_ 100u
R3 Net-_J5-Pin_3_ /NET0029 1k
C3 0 Net-_D1-K_ 100u
R15 Net-_J5-Pin_3_ Net-_J7-Pin_3_ 0
C2 0 Net-_D1-K_ 100u
R21 Net-_J7-Pin_3_ /NET0038 1k
R6 Net-_Q2-G_ Net-_J6-Pin_1_ 47k
R1 /NET0023 Net-_Q3-B_ 5.1k
R7 +3V3 /NET0023 10k
R22 Net-_Q3-C_ 0 20k

V_3V3 +3V3 0 DC 3.3

.control
tran 100u 10m
set filetype=ascii
write m5-pantilt_raw.raw all
.endc

.end
