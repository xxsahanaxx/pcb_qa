.title KiCad schematic

R4 /NET0037 /NET0033 0
R6 /NET0032 /NET0039 0
R20 /NET0037 /NET0005 0
R16 /NET0032 /NET0038 0
C6 +3V3 0 0.1u
R22 +3V3 /NET0026 2k
R21 +3V3 Net-_U2-B_ 2.2k
R14 Net-_U2-B_ 0 2.2k
R8 /NET0026 Net-_J1-Pin_3_ 0
R3 Net-_J1-Pin_3_ Net-_J5-Pin_3_ 0
C3 0 Net-_D1-K_ 100u
C5 0 Net-_D1-K_ 100u
R13 Net-_J5-Pin_3_ /NET0037 1k
C7 0 Net-_D1-K_ 100u
C4 Net-_D1-K_ 0 100u
R15 Net-_J1-Pin_3_ /NET0032 1k
R9 Net-_Q3-G_ Net-_J8-Pin_1_ 47k
R10 /NET0028 Net-_Q1-B_ 5.1k
R11 +3V3 /NET0028 10k
R18 Net-_Q1-C_ 0 20k

V_3V3 +3V3 0 DC 3.3

.control
tran 100u 10m
set filetype=ascii
write m5-pantilt_raw.raw all
.endc

.end
