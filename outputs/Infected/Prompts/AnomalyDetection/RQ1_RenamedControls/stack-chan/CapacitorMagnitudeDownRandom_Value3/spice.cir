.title KiCad schematic

R23 /NET0032 /NET0025 0
R8 /NET0021 /NET0010 0
R6 /NET0032 /NET0028 0
R14 /NET0021 /NET0037 0
C3 +3V3 0 0.1u
R3 +3V3 /NET0020 2k
R22 +3V3 Net-_U2-B_ 2.2k
R7 Net-_U2-B_ 0 2.2k
R4 /NET0020 Net-_J4-Pin_3_ 0
R18 Net-_J4-Pin_3_ Net-_J6-Pin_3_ 0
C6 0 Net-_D1-K_ 100u
C8 0 Net-_D1-K_ 100u
R17 Net-_J6-Pin_3_ /NET0032 1k
C2 0 Net-_D1-K_ 100u
C7 Net-_D1-K_ 0 100u
R20 Net-_J4-Pin_3_ /NET0021 1k
R19 Net-_Q3-G_ Net-_J8-Pin_1_ 47k
R12 /NET0004 Net-_Q1-B_ 5.1k
R11 +3V3 /NET0004 10k
R5 Net-_Q1-C_ 0 20k

V_3V3 +3V3 0 DC 3.3

.control
tran 100u 10m
set filetype=ascii
write m5-pantilt_raw.raw all
.endc

.end
