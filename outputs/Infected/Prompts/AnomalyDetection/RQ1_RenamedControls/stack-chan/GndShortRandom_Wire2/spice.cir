.title KiCad schematic

R15 /NET0040 /NET0013 0
R24 /NET0044 /NET0042 0
R7 /NET0040 /NET0023 0
R17 /NET0044 /NET0011 0
C3 +3V3 0 0.1u
R23 +3V3 /NET0033 2k
R3 +3V3 Net-_U2-B_ 2.2k
R5 Net-_U2-B_ 0 2.2k
R18 /NET0033 Net-_J10-Pin_3_ 0
R22 Net-_J10-Pin_3_ Net-_J9-Pin_3_ 0
C8 0 Net-_D1-K_ 100u
C5 0 Net-_D1-K_ 100u
R13 Net-_J9-Pin_3_ /NET0040 1k
C1 0 Net-_D1-K_ 100u
C4 Net-_D1-K_ 0 100u
R20 Net-_J10-Pin_3_ /NET0044 1k
R6 Net-_Q2-G_ Net-_J4-Pin_1_ 47k
R1 /NET0009 Net-_Q3-B_ 5.1k
R21 +3V3 /NET0009 10k
R9 Net-_Q3-C_ 0 20k

V_3V3 +3V3 0 DC 3.3

.control
tran 100u 10m
set filetype=ascii
write m5-pantilt_raw.raw all
.endc

.end
