.title KiCad schematic

R23 /NET0007 /NET0026 0
R1 /NET0011 /NET0024 0
R8 /NET0007 /NET0042 0
R12 /NET0011 /NET0002 0
C3 +3V3 0 0.1u
R5 +3V3 /NET0029 2k
R9 +3V3 Net-_U2-B_ 2.2k
R3 Net-_U2-B_ 0 2.2k
R19 /NET0029 Net-_J11-Pin_3_ 0
R14 Net-_J11-Pin_3_ Net-_J1-Pin_3_ 0
C4 0 Net-_D3-K_ 100u
C2 0 Net-_D3-K_ 100u
R22 Net-_J1-Pin_3_ /NET0007 1k
C7 0 Net-_D3-K_ 100u
C6 Net-_D3-K_ 0 100u
R11 Net-_J11-Pin_3_ /NET0011 1k
R4 Net-_Q2-G_ Net-_J10-Pin_1_ 47k
R20 /NET0013 Net-_Q3-B_ 5.1k
R17 +3V3 /NET0013 10k
R13 Net-_Q3-C_ 0 20k

V_3V3 +3V3 0 DC 3.3

.control
tran 100u 10m
set filetype=ascii
write m5-pantilt_raw.raw all
.endc

.end
