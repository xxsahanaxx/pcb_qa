.title KiCad schematic

R21 /NET0001 /NET0040 0
R2 /NET0032 /NET0020 0
R9 /NET0001 /NET0031 0
R3 /NET0032 /NET0008 0
C1 +3V3 0 0.1u
R18 +3V3 /NET0002 2k
R1 +3V3 Net-_U2-B_ 2.2k
R5 Net-_U2-B_ 0 2.2k
R12 /NET0002 Net-_J11-Pin_3_ 0
R14 Net-_J11-Pin_3_ Net-_J9-Pin_3_ 0
C3 0 Net-_D3-K_ 100u
C6 0 Net-_D3-K_ 100u
R20 Net-_J9-Pin_3_ /NET0001 1k
C2 0 Net-_D3-K_ 100u
C8 Net-_D3-K_ 0 100u
R11 Net-_J11-Pin_3_ /NET0032 1k
R16 Net-_Q2-G_ Net-_J10-Pin_1_ 47k
R23 /NET0006 Net-_Q3-B_ 5.1k
R13 +3V3 /NET0006 10k
R19 Net-_Q3-C_ 0 20k

V_3V3 +3V3 0 DC 3.3

.control
tran 100u 10m
set filetype=ascii
write m5-pantilt_raw.raw all
.endc

.end
