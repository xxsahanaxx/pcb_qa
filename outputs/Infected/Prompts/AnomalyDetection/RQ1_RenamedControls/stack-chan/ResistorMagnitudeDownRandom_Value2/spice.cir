.title KiCad schematic

R10 /NET0043 /NET0017 0
R17 /NET0018 /NET0013 0
R11 /NET0043 /NET0021 0
R21 /NET0018 /NET0003 0
C8 +3V3 0 0.1u
R3 +3V3 /NET0008 2k
R22 +3V3 Net-_U2-B_ 2.2k
R20 Net-_U2-B_ 0 2.2k
R13 /NET0008 Net-_J1-Pin_3_ 0
C4 Net-_D3-K_ 0 100u
C2 0 Net-_D3-K_ 100u
R8 Net-_J1-Pin_3_ /NET0018 1k
C1 0 Net-_D3-K_ 100u
R24 Net-_J1-Pin_3_ Net-_J7-Pin_3_ 0
C7 0 Net-_D3-K_ 100u
R19 Net-_J7-Pin_3_ /NET0043 1k
R12 Net-_Q3-G_ Net-_J9-Pin_1_ 47k
R1 /NET0025 Net-_Q1-B_ 5.1k
R16 +3V3 /NET0025 10k
R14 Net-_Q1-C_ 0 20k

V_3V3 +3V3 0 DC 3.3

.control
tran 100u 10m
set filetype=ascii
write m5-pantilt_raw.raw all
.endc

.end
