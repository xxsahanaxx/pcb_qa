.title KiCad schematic

R15 /NET0036 /NET0003 0
R10 /NET0008 /NET0022 0
R2 /NET0036 /NET0031 0
R19 /NET0008 /NET0026 0
C4 +3V3 0 0.1u
R17 +3V3 /NET0009 2k
R22 +3V3 Net-_U2-B_ 2.2k
R16 Net-_U2-B_ 0 2.2k
R8 /NET0009 Net-_J9-Pin_3_ 0
R1 Net-_J9-Pin_3_ Net-_J8-Pin_3_ 0
C8 0 Net-_D1-K_ 100u
C3 0 Net-_D1-K_ 100u
R21 Net-_J8-Pin_3_ /NET0036 1k
C2 0 Net-_D1-K_ 100u
C7 Net-_D1-K_ 0 100u
R18 Net-_J9-Pin_3_ /NET0008 1k
R11 Net-_Q2-G_ Net-_J1-Pin_1_ 47k
R5 /NET0040 Net-_Q3-B_ 5.1k
R7 +3V3 /NET0040 10k
R9 Net-_Q3-C_ 0 20k

V_3V3 +3V3 0 DC 3.3

.control
tran 100u 10m
set filetype=ascii
write m5-pantilt_raw.raw all
.endc

.end
