.title KiCad schematic

R12 /NET0002 /NET0025 0
R21 /NET0036 /NET0010 0
R15 /NET0002 /NET0029 0
R9 /NET0036 /NET0008 0
C8 +3V3 0 0.1u
R14 +3V3 /NET0028 2k
R3 +3V3 Net-_U2-B_ 2.2k
R16 Net-_U2-B_ 0 2.2k
R23 /NET0028 Net-_J10-Pin_3_ 0
R11 Net-_J10-Pin_3_ Net-_J7-Pin_3_ 0
C6 0 Net-_D3-K_ 100u
C3 0 Net-_D3-K_ 100u
R18 Net-_J7-Pin_3_ /NET0002 1k
C2 0 Net-_D3-K_ 100u
C5 Net-_D3-K_ 0 100u
R19 Net-_J10-Pin_3_ /NET0036 1k
R1 Net-_Q2-G_ Net-_J2-Pin_1_ 47k
R22 /NET0001 Net-_Q3-B_ 5.1k
R20 +3V3 /NET0001 10k
R4 Net-_Q3-C_ 0 20k

V_3V3 +3V3 0 DC 3.3

.control
tran 100u 10m
set filetype=ascii
write m5-pantilt_raw.raw all
.endc

.end
