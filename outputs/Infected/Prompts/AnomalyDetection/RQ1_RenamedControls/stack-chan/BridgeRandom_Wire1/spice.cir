.title KiCad schematic

R7 /NET0019 /NET0009 0
R8 /NET0027 /NET0030 0
R20 /NET0019 /NET0026 0
R22 /NET0027 /NET0032 0
C1 +3V3 0 0.1u
R3 +3V3 /NET0010 2k
R13 +3V3 Net-_U2-B_ 2.2k
R14 Net-_U2-B_ 0 2.2k
R9 /NET0010 Net-_J11-Pin_3_ 0
R4 Net-_J11-Pin_3_ Net-_J7-Pin_3_ 0
C4 0 Net-_D1-K_ 100u
C8 0 Net-_D1-K_ 100u
R16 Net-_J7-Pin_3_ /NET0019 1k
C3 0 Net-_D1-K_ 100u
C7 Net-_D1-K_ 0 100u
R15 Net-_J11-Pin_3_ /NET0027 1k
R21 Net-_Q3-G_ Net-_J2-Pin_1_ 47k
R18 /NET0001 Net-_Q1-B_ 5.1k
R12 +3V3 /NET0001 10k
R5 Net-_Q1-C_ 0 20k

V_3V3 +3V3 0 DC 3.3

.control
tran 100u 10m
set filetype=ascii
write m5-pantilt_raw.raw all
.endc

.end
