.title KiCad schematic

R16 /NET0033 /NET0027 0
R18 /NET0005 /NET0018 0
R23 /NET0033 /NET0013 0
R1 /NET0005 /NET0020 0
C4 +3V3 0 0.1u
R24 +3V3 /NET0038 2k
R13 +3V3 Net-_U2-B_ 2.2k
R2 Net-_U2-B_ 0 2.2k
R11 /NET0038 Net-_J6-Pin_3_ 0
R9 Net-_J6-Pin_3_ Net-_J11-Pin_3_ 0
C3 0 Net-_D3-K_ 100u
C5 0 Net-_D3-K_ 100u
R15 Net-_J11-Pin_3_ /NET0033 1k
C1 0 Net-_D3-K_ 100u
C8 Net-_D3-K_ 0 100u
R22 Net-_J6-Pin_3_ /NET0005 1k
R7 Net-_Q2-G_ Net-_J1-Pin_1_ 47k
R19 /NET0016 Net-_Q3-B_ 5.1k
R14 +3V3 /NET0016 10k
R4 Net-_Q3-C_ 0 20k

V_3V3 +3V3 0 DC 3.3

.control
tran 100u 10m
set filetype=ascii
write m5-pantilt_raw.raw all
.endc

.end
