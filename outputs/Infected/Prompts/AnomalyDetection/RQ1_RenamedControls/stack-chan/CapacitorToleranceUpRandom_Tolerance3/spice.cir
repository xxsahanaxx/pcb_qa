.title KiCad schematic

R7 /NET0030 /NET0012 0
R13 /NET0016 /NET0026 0
R16 /NET0030 /NET0002 0
R3 /NET0016 /NET0006 0
C1 +3V3 0 0.1u
R23 +3V3 /NET0025 2k
R18 +3V3 Net-_U2-B_ 2.2k
R14 Net-_U2-B_ 0 2.2k
R5 /NET0025 Net-_J7-Pin_3_ 0
R9 Net-_J7-Pin_3_ Net-_J1-Pin_3_ 0
C3 0 Net-_D3-K_ 100u
C6 0 Net-_D3-K_ 100u
R21 Net-_J1-Pin_3_ /NET0030 1k
C5 0 Net-_D3-K_ 100u
C4 Net-_D3-K_ 0 100u
R22 Net-_J7-Pin_3_ /NET0016 1k
R6 Net-_Q3-G_ Net-_J6-Pin_1_ 47k
R4 /NET0037 Net-_Q1-B_ 5.1k
R10 +3V3 /NET0037 10k
R2 Net-_Q1-C_ 0 20k

V_3V3 +3V3 0 DC 3.3

.control
tran 100u 10m
set filetype=ascii
write m5-pantilt_raw.raw all
.endc

.end
