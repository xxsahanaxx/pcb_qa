.title KiCad schematic

R14 /NET0038 /NET0027 0
R2 /NET0015 /NET0004 0
R19 /NET0038 /NET0022 0
R8 /NET0015 /NET0011 0
C7 +3V3 0 0.1u
R7 +3V3 /NET0013 2k
R21 +3V3 Net-_U2-B_ 2.2k
R12 Net-_U2-B_ 0 2.2k
R11 /NET0013 Net-_J5-Pin_3_ 0
C6 Net-_D1-K_ 0 100u
C1 0 Net-_D1-K_ 100u
R3 Net-_J5-Pin_3_ /NET0015 1k
C4 0 Net-_D1-K_ 100u
R5 Net-_J5-Pin_3_ Net-_J2-Pin_3_ 0
C5 0 Net-_D1-K_ 100u
R24 Net-_J2-Pin_3_ /NET0038 1k
R16 Net-_Q3-G_ Net-_J4-Pin_1_ 47k
R6 /NET0021 Net-_Q1-B_ 5.1k
R18 +3V3 /NET0021 10k
R20 Net-_Q1-C_ 0 20k

V_3V3 +3V3 0 DC 3.3

.control
tran 100u 10m
set filetype=ascii
write m5-pantilt_raw.raw all
.endc

.end
