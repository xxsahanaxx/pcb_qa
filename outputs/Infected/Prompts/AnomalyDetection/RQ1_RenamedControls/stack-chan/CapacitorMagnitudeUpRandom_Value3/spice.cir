.title KiCad schematic

R8 /NET0041 /NET0001 0
R16 /NET0023 /NET0030 0
R17 /NET0041 /NET0025 0
R2 /NET0023 /NET0009 0
C6 +3V3 0 0.1u
R7 +3V3 /NET0021 2k
R5 +3V3 Net-_U2-B_ 2.2k
R3 Net-_U2-B_ 0 2.2k
R13 /NET0021 Net-_J2-Pin_3_ 0
R24 Net-_J2-Pin_3_ Net-_J4-Pin_3_ 0
C1 0 Net-_D3-K_ 100u
C4 0 Net-_D3-K_ 100u
R22 Net-_J4-Pin_3_ /NET0041 1k
C3 0 Net-_D3-K_ 100u
C8 Net-_D3-K_ 0 100u
R12 Net-_J2-Pin_3_ /NET0023 1k
R1 Net-_Q2-G_ Net-_J3-Pin_1_ 47k
R23 /NET0034 Net-_Q3-B_ 5.1k
R6 +3V3 /NET0034 10k
R18 Net-_Q3-C_ 0 20k

V_3V3 +3V3 0 DC 3.3

.control
tran 100u 10m
set filetype=ascii
write m5-pantilt_raw.raw all
.endc

.end
