.title KiCad schematic

R4 /NET0042 /NET0022 0
R9 /NET0014 /NET0037 0
R14 /NET0042 /NET0027 0
R20 /NET0014 /NET0004 0
C3 +3V3 0 0.1u
R22 +3V3 /NET0001 2k
R5 +3V3 Net-_U2-B_ 2.2k
R24 Net-_U2-B_ 0 2.2k
R7 /NET0001 Net-_J5-Pin_3_ 0
R10 Net-_J5-Pin_3_ Net-_J8-Pin_3_ 0
C7 0 Net-_D1-K_ 100u
C4 0 Net-_D1-K_ 100u
R11 Net-_J8-Pin_3_ /NET0042 1k
C5 0 Net-_D1-K_ 100u
C6 Net-_D1-K_ 0 100u
R21 Net-_J5-Pin_3_ /NET0014 1k
R17 Net-_Q2-G_ Net-_J3-Pin_1_ 47k
R12 /NET0030 Net-_Q1-B_ 5.1k
R3 +3V3 /NET0030 10k
R6 Net-_Q1-C_ 0 20k

V_3V3 +3V3 0 DC 3.3

.control
tran 100u 10m
set filetype=ascii
write m5-pantilt_raw.raw all
.endc

.end
