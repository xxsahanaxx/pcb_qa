.title KiCad schematic

R2 /NET0006 /NET0011 0
R18 /NET0039 /NET0036 0
R13 /NET0006 /NET0035 0
R23 /NET0039 /NET0027 0
C4 +3V3 0 0.1u
R16 +3V3 /NET0014 2k
R24 +3V3 Net-_U2-B_ 2.2k
R21 Net-_U2-B_ 0 2.2k
R1 /NET0014 Net-_J9-Pin_3_ 0
R22 Net-_J9-Pin_3_ Net-_J4-Pin_3_ 0
C8 0 Net-_D3-K_ 100u
C6 0 Net-_D3-K_ 100u
R15 Net-_J4-Pin_3_ /NET0006 1k
C1 0 Net-_D3-K_ 100u
C5 Net-_D3-K_ 0 100u
R17 Net-_J9-Pin_3_ /NET0039 1k
R3 Net-_Q3-G_ Net-_J11-Pin_1_ 47k
R4 /NET0028 Net-_Q1-B_ 5.1k
R7 +3V3 /NET0028 10k
R11 Net-_Q1-C_ 0 20k

V_3V3 +3V3 0 DC 3.3

.control
tran 100u 10m
set filetype=ascii
write m5-pantilt_raw.raw all
.endc

.end
