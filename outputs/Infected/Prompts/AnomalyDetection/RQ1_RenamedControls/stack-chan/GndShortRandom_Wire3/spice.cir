.title KiCad schematic

R13 /NET0028 /NET0038 0
R19 /NET0027 /NET0017 0
R11 /NET0028 /NET0015 0
R18 /NET0027 /NET0019 0
C4 +3V3 0 0.1u
R7 +3V3 /NET0022 2k
R2 +3V3 Net-_U2-B_ 2.2k
R16 Net-_U2-B_ 0 2.2k
R1 /NET0022 Net-_J6-Pin_3_ 0
R10 Net-_J6-Pin_3_ Net-_J11-Pin_3_ 0
C7 0 Net-_D1-K_ 100u
C5 0 Net-_D1-K_ 100u
R9 Net-_J11-Pin_3_ /NET0028 1k
C3 0 Net-_D1-K_ 100u
C8 Net-_D1-K_ 0 100u
R24 Net-_J6-Pin_3_ /NET0027 1k
R14 Net-_Q2-G_ Net-_J4-Pin_1_ 47k
R17 /NET0032 Net-_Q3-B_ 5.1k
R12 +3V3 /NET0032 10k
R22 Net-_Q3-C_ 0 20k

V_3V3 +3V3 0 DC 3.3

.control
tran 100u 10m
set filetype=ascii
write m5-pantilt_raw.raw all
.endc

.end
