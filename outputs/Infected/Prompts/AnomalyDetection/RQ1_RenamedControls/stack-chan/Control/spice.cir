.title KiCad schematic

R17 /NET0032 /NET0026 0
R8 /NET0041 /NET0015 0
R4 /NET0032 /NET0040 0
R19 /NET0041 /NET0012 0
C4 +3V3 0 0.1u
R5 +3V3 /NET0022 2k
R10 +3V3 Net-_U2-B_ 2.2k
R3 Net-_U2-B_ 0 2.2k
R7 /NET0022 Net-_J9-Pin_3_ 0
R18 Net-_J9-Pin_3_ Net-_J10-Pin_3_ 0
C1 0 Net-_D1-K_ 100u
C7 0 Net-_D1-K_ 100u
R16 Net-_J10-Pin_3_ /NET0032 1k
C5 0 Net-_D1-K_ 100u
C2 Net-_D1-K_ 0 100u
R22 Net-_J9-Pin_3_ /NET0041 1k
R15 Net-_Q2-G_ Net-_J2-Pin_1_ 47k
R23 /NET0020 Net-_Q3-B_ 5.1k
R6 +3V3 /NET0020 10k
R20 Net-_Q3-C_ 0 20k

V_3V3 +3V3 0 DC 3.3

.control
tran 100u 10m
set filetype=ascii
write m5-pantilt_raw.raw all
.endc

.end
