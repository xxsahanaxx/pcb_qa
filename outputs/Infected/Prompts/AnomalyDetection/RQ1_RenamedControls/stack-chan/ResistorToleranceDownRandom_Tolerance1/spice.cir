.title KiCad schematic

R24 /NET0036 /NET0026 0
R17 /NET0024 /NET0028 0
R9 /NET0036 /NET0020 0
R19 /NET0024 /NET0001 0
C4 +3V3 0 0.1u
R1 +3V3 /NET0043 2k
R20 +3V3 Net-_U2-B_ 2.2k
R13 Net-_U2-B_ 0 2.2k
R3 /NET0043 Net-_J9-Pin_3_ 0
R10 Net-_J9-Pin_3_ Net-_J5-Pin_3_ 0
C6 0 Net-_D3-K_ 100u
C3 0 Net-_D3-K_ 100u
R12 Net-_J5-Pin_3_ /NET0036 1k
C1 0 Net-_D3-K_ 100u
C8 Net-_D3-K_ 0 100u
R22 Net-_J9-Pin_3_ /NET0024 1k
R8 Net-_Q2-G_ Net-_J2-Pin_1_ 47k
R15 /NET0029 Net-_Q3-B_ 5.1k
R11 +3V3 /NET0029 10k
R2 Net-_Q3-C_ 0 20k

V_3V3 +3V3 0 DC 3.3

.control
tran 100u 10m
set filetype=ascii
write m5-pantilt_raw.raw all
.endc

.end
