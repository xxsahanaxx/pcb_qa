.title KiCad schematic

R10 /NET0027 /NET0041 0
R22 /NET0019 /NET0040 0
R9 /NET0027 /NET0028 0
R12 /NET0019 /NET0018 0
C3 +3V3 0 0.1u
R4 +3V3 /NET0011 2k
R13 +3V3 Net-_U2-B_ 2.2k
R24 Net-_U2-B_ 0 2.2k
R8 /NET0011 Net-_J11-Pin_3_ 0
R23 Net-_J11-Pin_3_ Net-_J10-Pin_3_ 0
C4 0 Net-_D3-K_ 100u
C8 0 Net-_D3-K_ 100u
R1 Net-_J10-Pin_3_ /NET0027 1k
C6 0 Net-_D3-K_ 100u
C2 Net-_D3-K_ 0 100u
R21 Net-_J11-Pin_3_ /NET0019 1k
R18 Net-_Q3-G_ Net-_J1-Pin_1_ 47k
R19 /NET0002 Net-_Q1-B_ 5.1k
R14 +3V3 /NET0002 10k
R3 Net-_Q1-C_ 0 20k

V_3V3 +3V3 0 DC 3.3

.control
tran 100u 10m
set filetype=ascii
write m5-pantilt_raw.raw all
.endc

.end
