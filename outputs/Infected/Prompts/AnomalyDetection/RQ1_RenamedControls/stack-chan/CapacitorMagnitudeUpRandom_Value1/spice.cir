.title KiCad schematic

R17 /NET0022 /NET0017 0
R9 /NET0038 /NET0013 0
R12 /NET0022 /NET0041 0
R1 /NET0038 /NET0021 0
C2 +3V3 0 0.1u
R13 +3V3 /NET0036 2k
R4 +3V3 Net-_U2-B_ 2.2k
R23 Net-_U2-B_ 0 2.2k
R10 /NET0036 Net-_J11-Pin_3_ 0
C4 Net-_D3-K_ 0 100u
C5 0 Net-_D3-K_ 100u
R8 Net-_J11-Pin_3_ /NET0038 1k
C1 0 Net-_D3-K_ 100u
R7 Net-_J11-Pin_3_ Net-_J8-Pin_3_ 0
C6 0 Net-_D3-K_ 100u
R14 Net-_J8-Pin_3_ /NET0022 1k
R24 Net-_Q2-G_ Net-_J9-Pin_1_ 47k
R18 /NET0032 Net-_Q3-B_ 5.1k
R22 +3V3 /NET0032 10k
R6 Net-_Q3-C_ 0 20k

V_3V3 +3V3 0 DC 3.3

.control
tran 100u 10m
set filetype=ascii
write m5-pantilt_raw.raw all
.endc

.end
