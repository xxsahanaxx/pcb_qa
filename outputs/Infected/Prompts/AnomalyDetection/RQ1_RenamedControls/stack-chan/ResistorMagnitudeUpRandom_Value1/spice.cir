.title KiCad schematic

R18 /NET0026 /NET0010 0
R1 /NET0036 /NET0025 0
R11 /NET0026 /NET0027 0
R14 /NET0036 /NET0023 0
C1 +3V3 0 0.1u
R24 +3V3 /NET0007 2k
R5 +3V3 Net-_U2-B_ 2.2k
R23 Net-_U2-B_ 0 2.2k
R3 /NET0007 Net-_J10-Pin_3_ 0
R6 Net-_J10-Pin_3_ Net-_J7-Pin_3_ 0
C8 0 Net-_D1-K_ 100u
C2 0 Net-_D1-K_ 100u
R17 Net-_J7-Pin_3_ /NET0026 1k
C7 0 Net-_D1-K_ 100u
C4 Net-_D1-K_ 0 100u
R20 Net-_J10-Pin_3_ /NET0036 1k
R13 Net-_Q2-G_ Net-_J1-Pin_1_ 47k
R21 /NET0039 Net-_Q1-B_ 5.1k
R9 +3V3 /NET0039 10k
R19 Net-_Q1-C_ 0 20k

V_3V3 +3V3 0 DC 3.3

.control
tran 100u 10m
set filetype=ascii
write m5-pantilt_raw.raw all
.endc

.end
