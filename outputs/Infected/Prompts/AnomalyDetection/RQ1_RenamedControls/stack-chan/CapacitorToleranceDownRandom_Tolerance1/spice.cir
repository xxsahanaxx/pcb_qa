.title KiCad schematic

R5 /NET0027 /NET0012 0
R23 /NET0010 /NET0030 0
R21 /NET0027 /NET0038 0
R2 /NET0010 /NET0028 0
C2 +3V3 0 0.1u
R20 +3V3 /NET0016 2k
R17 +3V3 Net-_U2-B_ 2.2k
R18 Net-_U2-B_ 0 2.2k
R10 /NET0016 Net-_J2-Pin_3_ 0
C8 Net-_D3-K_ 0 100u
C6 0 Net-_D3-K_ 100u
R8 Net-_J2-Pin_3_ /NET0010 1k
C7 0 Net-_D3-K_ 100u
R3 Net-_J2-Pin_3_ Net-_J4-Pin_3_ 0
C4 0 Net-_D3-K_ 100u
R4 Net-_J4-Pin_3_ /NET0027 1k
R12 Net-_Q2-G_ Net-_J11-Pin_1_ 47k
R14 /NET0032 Net-_Q3-B_ 5.1k
R9 +3V3 /NET0032 10k
R22 Net-_Q3-C_ 0 20k

V_3V3 +3V3 0 DC 3.3

.control
tran 100u 10m
set filetype=ascii
write m5-pantilt_raw.raw all
.endc

.end
