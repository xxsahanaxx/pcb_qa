.title KiCad schematic

R12 /NET0017 /NET0035 0
R16 /NET0029 /NET0001 0
R2 /NET0017 /NET0025 0
R9 /NET0029 /NET0042 0
C1 +3V3 0 0.1u
R14 +3V3 /NET0022 2k
R20 +3V3 Net-_U2-B_ 2.2k
R10 Net-_U2-B_ 0 2.2k
R22 /NET0022 Net-_J2-Pin_3_ 0
C5 Net-_D3-K_ 0 100u
C2 0 Net-_D3-K_ 100u
R3 Net-_J2-Pin_3_ /NET0029 1k
C7 0 Net-_D3-K_ 100u
R4 Net-_J2-Pin_3_ Net-_J5-Pin_3_ 0
C4 0 Net-_D3-K_ 100u
R19 Net-_J5-Pin_3_ /NET0017 1k
R24 Net-_Q3-G_ Net-_J9-Pin_1_ 47k
R15 /NET0026 Net-_Q1-B_ 5.1k
R6 +3V3 /NET0026 10k
R17 Net-_Q1-C_ 0 20k

V_3V3 +3V3 0 DC 3.3

.control
tran 100u 10m
set filetype=ascii
write m5-pantilt_raw.raw all
.endc

.end
