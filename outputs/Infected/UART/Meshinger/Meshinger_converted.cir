.title KiCad schematic

R2 Net-_Q2-G_ +3V3 10k
C4 0 Net-_U2-K_ 1uF
C3 Net-_U1-A_ Net-_Q1-D_ 4.7uF
C6 0 Net-_U3-A_ 1uF
C2 0 Display_Power_Switch 1uF
L1 Net-_Q1-D_ Display_Power_Switch 10u
R1 Net-_Q1-S_ 0 0.47
C1 0 Display_Power_Switch 0.1uF
C8 Net-_C8-Pad1_ 0 1uF
C10 Net-_C10-Pad1_ 0 1uF
C9 Net-_C9-Pad1_ 0 1uF
C7 Net-_C7-Pad1_ 0 1uF
C5 Net-_C5-Pad1_ 0 1uF
C12 BAT+ 0 2.2u
L2 Net-_IC1-SW_ +3V3 1.0u
C13 +3V3 0 10u
C11 unconnected-_C11-Pad1_ 0 0.1u

V_3V3 +3V3 0 DC 3.3

.control
tran 100u 10m
set filetype=ascii
write /Users/sahanasrinivasan/Library/CloudStorage/OneDrive-UNSW/ComplexAutomatedLLMTDIS/pcb_qa/outputs/Infected/UART/Meshinger/Meshinger_converted_raw.raw all
.endc

.end
