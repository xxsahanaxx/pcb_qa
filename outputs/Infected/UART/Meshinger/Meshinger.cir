.title KiCad schematic
U4 __U4
J2 __J2
R2 Net-_Q2-G_ +3V3 10k
Q2 __Q2
U5 __U5
U2 __U2
C4 GND Net-_U2-K_ 1uF
C3 Net-_U1-A_ Net-_Q1-D_ 4.7uF
C6 GND Net-_U3-A_ 1uF
U3 __U3
U1 __U1
C2 GND Display_Power_Switch 1uF
L1 Net-_Q1-D_ Display_Power_Switch 10u
Q1 __Q1
R1 Net-_Q1-S_ GND 0.47
C1 GND Display_Power_Switch 0.1uF
J1 __J1
C8 Net-_C8-Pad1_ GND 1uF
C10 Net-_C10-Pad1_ GND 1uF
C9 Net-_C9-Pad1_ GND 1uF
C7 Net-_C7-Pad1_ GND 1uF
C5 Net-_C5-Pad1_ GND 1uF
J3 __J3
U6 __U6
U7 __U7
C12 BAT+ GND 2.2u
L2 Net-_IC1-SW_ +3V3 1.0u
IC1 __IC1
C13 +3V3 GND 10u
J5 __J5
C11 unconnected-_C11-Pad1_ GND 0.1u
J4 __J4
J6 __J6
J7 __J7
S1 __S1
.end
