.title KiCad schematic

R2 PWM Net-_Q2-B_ 1k
R3 +5V RST 10k
R6 0 TACH 10k
R1 0 Net-_Q1-G_ 10k
C1 0 0 100n
C2 +5V 0 100n
R5 /PWM_OUT PWM 1k
R4 TACH /TACH_IN 1k

V_5V +5V 0 DC 5.0

.control
tran 100u 10m
set filetype=ascii
write ./outputs/Infected/GndShortRef/C1/fan_controller/fan_controller_raw.raw all
.endc

.end
