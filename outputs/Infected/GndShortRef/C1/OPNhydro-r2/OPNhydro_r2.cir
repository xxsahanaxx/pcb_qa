.title KiCad schematic

C3 +5V +24V 100n
R9 +5V FLOAT_HIGH 10k
C5 FLOAT_HIGH +3V3 100n
R6 FLOAT_LOW +3V3 10k
C4 +5V FLOAT_LOW 100n
C1 +5V +5V 100u
R12 +5V /GATO 10k
R10 ATO_VALVE /GATO 100
C11 +5V +24V 100n
C9 +24V +5V 47u
R2 FLOAT_LOW /BPUMP 4.7k
R11 FLOAT_HIGH /BATO 4.7k
R1 PUMP_MAIN /GPUMP 100
C2 +24V +5V 220u
R5 /GPUMP +3V3 10k
R24 /VREFpH pH 14k
C40 +5V pH 2.2u
C19 /0ISOEC /VISOEC 10u
C25 /VEC /0ISOEC 10n
C20 /VEC /0ISOEC 100n
C24 /0ISOEC /VISOEC 100n
C34 +5V +3V3 100n
C38 +5V +3V3 10u
C35 +3V3 +5V 10n
C39 +3V3 +5V 100n
R16 /SDApH /VpH 2.2k
C13 +5V +3V3 100n
C14 +5V +3V3 10u
R19 /SCLEC /VEC 2.2k
R17 /SDAEC /VEC 2.2k
R34 /BRApH +5V 110m
C43 +5V +3V3 100n
C52 +5V +24V 100n
C55 +5V +24V 100n
C46 /CP0pH /CP1pH 22n
C49 /VCPpH +24V 100n
C58 +24V +5V 220u
C59 +24V +5V 220u
C60 +24V +5V 220u
R7 /GRPP /+24VF 33k
C10 +5V /SSBK 33n
C6 +24V +5V 1000u
C37 +3V3 +5V 100n
C33 +3V3 +5V 10n
R4 I2C_SCL +3V3 2.2k
R3 I2C_SDA +3V3 2.2k
R8 Net-_M1A-TX1/IO22_ STEP_BUS 1k
C8 +5V +24V 100n
C7 +5V +24V 10u
C23 /VpH /0ISOpH 10n
C18 /VpH /0ISOpH 100n
R22 /VSELpH /0ISOpH 10k
R20 /VSELpH /VpH 16.9k
R18 /SCLpH /VpH 2.2k
C15 +5V +5V 10u
R14 8BK +5V 52.3k
R15 +5V 8BK 10k
C16 +5V +5V 10u
C17 /0ISOpH /VISOpH 10u
L1 /+5VBK +5V 10u
C12 /BSTBK /+5VBK 100n
R13 +5V /RTBK 21k
C21 +5V +5V 10u
C36 +5V +3V3 10u
C32 +5V +3V3 100n
C26 +5V +5V 220u
C27 +5V +3V3 22u
C22 /0ISOpH /VISOpH 100n
R35 /BRBpH +5V 110m
C56 +5V +24V 100n
C53 +5V +24V 100n
C50 /VCPNA +24V 100n
R25 +5V /VREFpH 10.7k
C47 /CP0NA /CP1NA 22n
C44 +5V +3V3 100n
R27 +5V /VREFNA 10.7k
R26 /VREFNA NA 14k
R31 /BRBNA +5V 110m
R30 /BRANA +5V 110m
R28 /VREFNB NB 14k
C42 +5V NB 2.2u
R29 +5V /VREFNB 10.7k
C41 +5V NA 2.2u
C54 +5V +24V 100n
C57 +5V +24V 100n
C51 /VCPNB +24V 100n
C45 +5V +3V3 100n
C48 /CP0NB /CP1NB 22n
R33 /BRBNB +5V 110m
R32 /BRANB +5V 110m
C30 +5V +3V3 10u
C31 +5V +3V3 10u
C29 +5V +3V3 100n
R21 /VSELEC /VEC 16.9k
R23 /VSELEC /0ISOEC 10k
C28 +5V +3V3 100n

V_24V +24V 0 DC 24.0
V_3V3 +3V3 0 DC 3.3
V_5V +5V 0 DC 5.0

.control
tran 100u 10m
set filetype=ascii
write ./outputs/Infected/GndShortRef/C1/OPNhydro-r2/OPNhydro_r2_raw.raw all
.endc

.end
