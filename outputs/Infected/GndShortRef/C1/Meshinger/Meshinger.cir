.title KiCad schematic

R2 Net-_Q2-G_ +3V3 10k
C4 Display_Power_Switch Net-_U2-K_ 1uF
C3 Net-_U1-A_ Net-_Q1-D_ 4.7uF
C6 Display_Power_Switch Net-_U3-A_ 1uF
C2 Display_Power_Switch Display_Power_Switch 1uF
L1 Net-_Q1-D_ Display_Power_Switch 10u
R1 Net-_Q1-S_ Display_Power_Switch 0.47
C1 Display_Power_Switch Display_Power_Switch 0.1uF
C8 Net-_C8-Pad1_ Display_Power_Switch 1uF
C9 Net-_C9-Pad1_ Display_Power_Switch 1uF
C7 Net-_C7-Pad1_ Display_Power_Switch 1uF
C10 Net-_C10-Pad1_ Display_Power_Switch 1uF
C5 Net-_C5-Pad1_ Display_Power_Switch 1uF
C11 unconnected-_C11-Pad1_ Display_Power_Switch 0.1u
C13 +3V3 Display_Power_Switch 10u
C12 BAT+ Display_Power_Switch 2.2u

V_3V3 +3V3 0 DC 3.3
V_BAT_ BAT+ 0 DC 25.0

.control
tran 100u 10m
set filetype=ascii
write ./outputs/Infected/GndShortRef/C1/Meshinger/Meshinger_raw.raw all
.endc

.end
