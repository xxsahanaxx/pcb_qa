.title KiCad schematic

.model __D3 D
.model __D4 D
.model __D7 D
.model LED D (Is=1p Rs=10 N=1.7)

R7 +12V Net-_J12-CC2_ 5.1k
R1 +12V Net-_J12-CC1_ 5.1k
C12 +3V3 +12V 1u
R3 Net-_D2-K_ +12V 500
D2 Net-_D2-K_ /Microcontroller/HEATER LED
C1 +12V +12V 0.1u
R6 Net-_U1-GPIO2/ADC1_CH2_ +3V3 10k
D3 NC-D3-0 Net-_D3-A_ __D3
D4 NC-D4-0 Net-_D4-A_ __D4
R11 Net-_D4-A_ +3V3 10k
R2 Net-_D3-A_ +3V3 10k
C7 Net-_U1-EN/CHIP_PU_ +12V 10u
R5 Net-_U1-EN/CHIP_PU_ +3V3 10k
C8 +3V3 +12V 1u
C3 +3V3 +12V 1u
C4 +3V3 +12V 1u
C6 +3V3 +12V 1u
L1 Net-_U8-SW_ +3V3 3.9u
C11 VBUS +12V 10u
C13 Net-_U8-SW_ Net-_U8-BST_ 100n
C9 +3V3 +12V 22u
C10 +3V3 +12V 22u
D7 +12V +12V __D7
C5 Net-_U5-SS_ +12V 10n
R12 Net-_U5-ILIM_ +12V 51.1k
C2 +12V +12V 10u

V_12V +12V 0 DC 12.0
V_3V3 +3V3 0 DC 3.3

.control
tran 100u 10m
set filetype=ascii
write ./outputs/Infected/GndShortRef/C1/CF-Chef/controller_raw.raw all
.endc

.end
