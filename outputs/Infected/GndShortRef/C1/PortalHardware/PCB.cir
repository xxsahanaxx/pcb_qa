.title KiCad schematic

C9 0 0 4.7u
C1 0 0 4.7u
R10 0 NRST 10k
R8 TSC_G2_IO2 Net-_A2-BTN_ 1k
C14 0 TSC_G2_IO4 22n
C5 0 0 100n
C4 0 0 100n
C6 0 0 100n
C2 0 0 100n
C3 0 0 100n
C8 0 0 100n
R1 NFC_SDA 0 10k
R2 NFC_SCL 0 10k
R3 NFC_INT 0 10k
R4 DISP_RES 0 10k
R6 DISP_SCL 0 10k
R7 DISP_SDA 0 10k
C13 Net-_U4-C2N_ Net-_U4-C2P_ 1u
C12 Net-_U4-C1N_ Net-_U4-C1P_ 1u
C11 Net-_U4-VCOMH_ 0 4.7u
C7 Net-_U4-VCC_ 0 2.2u
R5 0 Net-_U4-IREF_ 390k
C17 0 0 1u
C10 0 0 1u

.control
tran 1m 10m
set filetype=ascii
write ./outputs/Infected/GndShortRef/C1/PortalHardware/PCB_raw.raw all
.endc

.end
