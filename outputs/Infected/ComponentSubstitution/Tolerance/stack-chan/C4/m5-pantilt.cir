.title KiCad schematic

R10 /PWM1 /PWM1_C2 0
R11 /PWM2 /PWM2_C1 0
R12 /PWM2 /PWM2_C2 0
R9 /PWM1 /PWM1_C1 0
C5 +3V3 0 0.1u
R6 +3V3 /TTL 2k
R8 +3V3 Net-_U1-B_ 2.2k
R15 Net-_U1-B_ 0 2.2k
C4 0 Net-_D2-K_ 100u
R13 Net-_J8-Pin_3_ Net-_J3-Pin_3_ 0
C3 Net-_D2-K_ 0 100u
R4 Net-_J8-Pin_3_ /PWM2 1k
R14 /TTL Net-_J8-Pin_3_ 0
C1 0 Net-_D2-K_ 100u
R3 Net-_J3-Pin_3_ /PWM1 1k
C2 0 Net-_D2-K_ 100u
R5 Net-_Q1-G_ Net-_J5-Pin_1_ 47k
R2 /TXD2 Net-_Q2-B_ 5.1k
R1 +3V3 /TXD2 10k
R7 Net-_Q2-C_ 0 20k

V_3V3 +3V3 0 DC 3.3

.control
tran 100u 10m
set filetype=ascii
write ./outputs/Infected/ComponentSubstitution/Tolerance/stack-chan/C4/m5-pantilt_raw.raw all
.endc

.end
