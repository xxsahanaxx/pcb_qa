.title KiCad schematic

.model LED_D_G D (Is=1p Rs=10 N=1.7)
.model LED_D_B D (Is=1p Rs=10 N=1.7)
.model LED_D_Y D (Is=1p Rs=10 N=1.7)
.model LED_D_R D (Is=1p Rs=10 N=1.7)

R1 REG_VIN VIN+ 0.01
C10 +3.3V 0 100n
C7 +5V REG_FB 4.7n
R5 +5V REG_FB 6.8k
L1 REG_CS +5V 15u
C9 +5V 0 47u
C8 +5V 0 100u
C6 REG_CS Net-_C6-Pad2_ 100n
C5 REG_CS REG_BST 100n
R4 Net-_C6-Pad2_ REG_FB 19.6k
R6 0 REG_FB 1.3k
R7 0 Net-_LED1-K_ 560
DLED1 Net-_LED1-K_ +5V LED_D_G
R3 REG_PG Net-_D1-A_ 10k
C4 Net-_D1-A_ 0 2.2u
C3 Net-_REG1-PVDD_ 0 2.2u
R2 REG_VIN REG_EN 10k
C1 REG_VIN 0 100u
C2 REG_VIN 0 47u
R8 0 Net-_LED2-K_ 240
DLED2 Net-_LED2-K_ +3.3V LED_D_G
C11 +5V 0 10u
C12 +3.3V 0 10u
C32 HSE_IN_FCC 0 10p
C33 Net-_C33-Pad1_ 0 10p
R23 HSE_OUT_FCC Net-_C33-Pad1_ 620
C18 +3V3 0 100n
C16 +3V3 0 100n
R11 +3V3 I2C2_SCL_FCC 4.7k
R12 +3V3 I2C2_SDA_FCC 4.7k
R10 +3V3 I2C1_SDA_FCC 4.7k
C17 +3V3 0 100n
R9 +3V3 I2C1_SCL_FCC 4.7k
C19 +3V3 0 100n
DLED8 Net-_LED8-K_ LED_F_FCC LED_D_B
R20 0 Net-_LED8-K_ 100
R13 +3V3 I2C3_SCL_FCC 4.7k
R14 +3V3 I2C3_SDA_FCC 4.7k
C30 VREF+_FCC 0 100n
R21 VREF+_FCC VDDA_FCC 47
C28 VDDA_FCC 0 100n
R16 0 Net-_LED4-K_ 330
R15 0 Net-_LED3-K_ 330
DLED7 Net-_LED7-K_ LED_E_FCC LED_D_B
R19 0 Net-_LED7-K_ 100
C31 NRST_FCC 0 100n
R17 0 Net-_LED5-K_ 330
DLED6 Net-_LED6-K_ LED_D_FCC LED_D_B
DLED5 Net-_LED5-K_ LED_C_FCC LED_D_Y
R18 0 Net-_LED6-K_ 100
DLED4 Net-_LED4-K_ LED_B_FCC LED_D_R
DLED3 Net-_LED3-K_ LED_A_FCC LED_D_R
C20 +3V3 0 100n
C21 +3V3 0 100n
C22 +3V3 0 100n
C24 +3V3 0 100n
C25 +3V3 0 100n
C23 +3V3 0 100n
C26 +3V3 0 100n
C14 Net-_FCC1-PH0_ 0 2.2u
C13 unconnected-_C13-Pad1_ 0 2.2u
R22 Net-_SW2-C_ BOOT0_FCC 10k
R32 HSE_OUT_NAVC Net-_C53-Pad1_ 620
C53 Net-_C53-Pad1_ 0 10p
C52 HSE_IN_NAVC 0 10p
R28 +3V3 I2C1_SCL_NAVC 4.7k
DLED11 Net-_LED11-K_ LED_C_NAVC LED_D_Y
DLED12 Net-_LED12-K_ LED_D_NAVC LED_D_B
R35 0 Net-_LED11-K_ 330
R36 0 Net-_LED12-K_ 100
R30 +3V3 I2C3_SCL_NAVC 4.7k
R29 +3V3 I2C1_SDA_NAVC 4.7k
R31 +3V3 I2C3_SDA_NAVC 4.7k
R34 0 Net-_LED10-K_ 330
R33 0 Net-_LED9-K_ 330
DLED9 Net-_LED9-K_ LED_A_NAVC LED_D_R
DLED10 Net-_LED10-K_ LED_B_NAVC LED_D_R
C38 Net-_NAVC1-PH1_ 0 2.2u
C37 Net-_NAVC1-PH0_ 0 2.2u
C41 +3V3 0 100n
C40 +3V3 0 100n
C47 +3V3 0 100n
C48 +3V3 0 100n
C43 +3V3 0 100n
C45 +3V3 0 100n
C46 +3V3 0 100n
C42 +3V3 0 100n
C44 +3V3 0 100n
C51 VDDA_NAVC 0 100n
C49 NRST_NAVC 0 100n
R26 Net-_SW3-C_ BOOT0_NAVC 10k
R27 Net-_SW4-C_ BOOT1_NAVC 10k
R46 GPIO_G_NAVC GPIO_G_FCC 10
R44 GPIO_E_NAVC GPIO_E_FCC 10
R45 GPIO_F_NAVC GPIO_F_FCC 10
R47 GPIO_H_NAVC GPIO_H_FCC 10
R40 GPIO_A_NAVC GPIO_A_FCC 10
R43 GPIO_D_NAVC GPIO_D_FCC 10
R41 GPIO_B_NAVC GPIO_B_FCC 10
R42 GPIO_C_NAVC GPIO_C_FCC 10
R53 USB_DM_FCC Net-_USB1-D-_ 22
R54 USB_ID_FCC Net-_USB1-ID_ 560
R52 USB_DP_FCC Net-_USB1-D+_ 22
R55 USB_DP_NAVC Net-_USB2-D+_ 22
R56 USB_DM_NAVC Net-_USB2-D-_ 22
R57 USB_ID_NAVC Net-_USB2-ID_ 560
C69 0 unconnected-_C69-Pad2_ 100n
C68 0 Net-_D4-A_ 100n
DLED13 Net-_LED13-K_ Net-_D4-A_ LED_D_G
R58 0 Net-_LED13-K_ 560
C71 0 unconnected-_C71-Pad2_ 100n
C70 0 Net-_D5-A_ 100n
DLED14 Net-_LED14-K_ Net-_D5-A_ LED_D_G
R59 0 Net-_LED14-K_ 560
R48 UART2_TX_NAVC UART2_RX_FCC 10
R49 UART2_RX_NAVC UART2_TX_FCC 10
R50 I2C2_SCL_NAVC I2C1_SCL_FCC 0
R51 I2C2_SDA_NAVC I2C1_SDA_FCC 0
C34 +3.3V 0 100n
R25 +3.3V Net-_U4-_WP__IO2__ 10k
R24 +3.3V Net-_U4-_HOLD__IO3__ 10k
C35 +3.3V 0 100n
C36 0 +3.3V 100n
C54 +3.3V 0 100n
C55 +3.3V 0 100n
C65 +3.3V 0 1u
C64 +3.3V 0 1u
C60 +3.3V 0 100n
C59 Net-_U8-C1_ 0 220n
C61 +3.3V 0 100n
C62 +3.3V 0 10u
R38 +3.3V GPS_NRST_NAVC 10k
L2 Net-_L2-Pad1_ Net-_ANT1-Pad1_ 27n
C67 Net-_ANT1-Pad1_ 0 10n
C66 Net-_ANT1-Pad1_ Net-_U10-RF_IN_ 22p
R39 Net-_L2-Pad1_ Net-_U10-VCC_RF_ 10
C56 +3.3V 0 100n
C63 +3.3V 0 100n
C57 Net-_U7-VO-_ Net-_U7-VO+_ 1n
C58 +3.3V 0 100n
R37 +3.3V BAR_NRST_NAVC 10k

V_3_3V +3.3V 0 DC 3.3
V_3V3 +3V3 0 DC 3.3
V_5V +5V 0 DC 5.0

.control
tran 100u 10m
set filetype=ascii
write ./outputs/Infected/ComponentSubstitution/Tolerance/HadesFCS/R57/Hades_raw.raw all
.endc

.end
